[IBIS Ver]   5.0
[File Name]   as4c1g32md4v-046bin.ibs
[File Rev]   1.0
[Date]   2024-04-03
[Source]   File originated from Alliance Memory Inc.
   The Following information corresponds to the
   32Gb LPDDR4X 2ch. X32 Die.
[Notes]   Rev 1.0 : 03, Apr. 2024
   File checked by IBISCHK7 V7.2.0.
   While ibischk may report monotonicity warnings,
   the non-monotonic points are not in the "active region"
   of the device.
[Disclaimer] This IBIS model provided "as is" with no warranty and AM
                is not responsible for any problems this model may cause to
                the customers. Customers may only modify the IBIS model to
                fit their particular application.
[Copyright]   Copyright 2024. Alliance Memory Inc. All rights reserved.
[Component]   AS4C1G32MD4V-046BIN
[Manufacturer]  Alliance Memory Inc.
[Package]   |200-BALL FBGA (10.0 X 15.0 X 1.0)
|   typ   min   max
R_pkg   1.423Ohm   1.046Ohm   4.177Ohm
L_pkg   2.150nH   1.672nH   5.148nH
C_pkg   1.026pF   0.772pF   3.790pF
[Pin] signal_name model_name R_pin L_pin C_pin
A1   DNU   NC
A2   DNU   NC
A3   VSS   GND
A4   VDD2   POWER
A5   ZQ0   NC
A8   ZQ1   NC
A9   VDD2   POWER
A10   VSS   GND
A11   DNU   NC
A12   DNU   NC
B1   DNU   NC
B2   DQ0_a   DQ_PIN   1.126  1.773nH  0.831pF
B3   VDDQ   POWER
B4   DQ7_a   DQ_PIN   1.120  1.738nH  0.850pF
B5   VDDQ   POWER
B8   VDDQ   POWER
B9   DQ15_a   DQ_PIN   1.127  1.744nH  0.814pF
B10   VDDQ   POWER
B11   DQ8_a   DQ_PIN   1.101  1.739nH  0.837pF
B12   DNU   NC
C1   VSS   GND
C2   DQ1_a   DQ_PIN   1.074  1.735nH  0.858pF
C3   DMI0_a   DQ_PIN   1.112  1.838nH  0.827pF
C4   DQ6_a   DQ_PIN   1.075  1.713nH  0.855pF
C5   VSS   GND
C8   VSS   GND
C9   DQ14_a   DQ_PIN   1.059  1.680nH  0.839pF
C10   DMI1_a   DQ_PIN   1.095  1.774nH  0.865pF
C11   DQ9_a   DQ_PIN   1.088  1.730nH  0.834pF
C12   VSS   GND
D1   VDDQ   POWER
D2   VSS   GND
D3   DQS0_t_a   DQ_PIN   1.187  1.878nH  0.834pF
D4   VSS   GND
D5   VDDQ   POWER
D8   VDDQ   POWER
D9   VSS   GND
D10   DQS1_t_a   DQ_PIN   1.177  1.868nH  0.826pF
D11   VSS   GND
D12   VDDQ   POWER
E1   VSS   GND
E2   DQ2_a   DQ_PIN   1.908  2.656nH  1.283pF
E3   DQS0_c_a   DQ_PIN   1.229  1.946nH  0.837pF
E4   DQ5_a   DQ_PIN   1.129  1.763nH  0.868pF
E5   VSS   GND
E8   VSS   GND
E9   DQ13_a   DQ_PIN   1.118  1.730nH  0.842pF
E10   DQS1_c_a   DQ_PIN   1.217  1.930nH  0.832pF
E11   DQ10_a   DQ_PIN   1.130  1.823nH  0.793pF
E12   VSS   GND
F1   VDD1   POWER
F2   DQ3_a   DQ_PIN   1.232  1.881nH  0.847pF
F3   VDDQ   POWER
F4   DQ4_a   DQ_PIN   1.167  1.813nH  0.813pF
F5   VDD2   POWER
F8   VDD2   POWER
F9   DQ12_a   DQ_PIN   1.158  1.788nH  0.838pF
F10   VDDQ   POWER
F11   DQ11_a   DQ_PIN   1.168  1.851nH  0.824pF
F12   VDD1   POWER
G1   VSS   GND
G2   ODT_CA_a   CKE_PIN   1.635  2.199nH  1.210pF
G3   VSS   GND
G4   VDD1   POWER
G5   VSS   GND
G8   VSS   GND
G9   VDD1   POWER
G10   VSS   GND
G11   NC   NC
G12   VSS   GND
H1   VDD2   POWER
H2   CA0_a   CA_PIN   1.925  2.748nH  1.293pF
H3   CS1_a   CS_PIN   1.969  2.796nH  1.267pF
H4   CS0_a   CS_PIN   1.638  2.252nH  1.234pF
H5   VDD2   POWER
H8   VDD2   POWER
H9   CA2_a   CA_PIN   1.908  2.656nH  1.283pF
H10   CA3_a   CA_PIN   1.897  2.692nH  1.263pF
H11   CA4_a   CA_PIN   1.841  2.666nH  1.294pF
H12   VDD2   POWER
J1   VSS   GND
J2   CA1_a   CA_PIN   1.901  2.680nH  1.272pF
J3   VSS   GND
J4   CKE0_a   CKE_PIN   1.495  2.136nH  1.210pF
J5   CKE1_a   CKE_PIN   1.728  2.668nH  1.218pF
J8   CK_t_a   CLK_PIN   1.952  2.755nH  1.249pF
J9   CK_c_a   CLK_PIN   1.968  2.683nH  1.274pF
J10   VSS   GND
J11   CA5_a   CA_PIN   1.973  2.770nH  1.300pF
J12   VSS   GND
K1   VDD2   POWER
K2   VSS   GND
K3   VDD2   POWER
K4   VSS   GND
K5   NC   NC
K8   NC   NC
K9   VSS   GND
K10   VDD2   POWER
K11   VSS   GND
K12   VDD2   POWER
N1   VDD2   POWER
N2   VSS   GND
N3   VDD2   POWER
N4   VSS   GND
N5   NC   NC
N8   NC   NC
N9   VSS   GND
N10   VDD2   POWER
N11   VSS   GND
N12   VDD2   POWER
P1   VSS   GND
P2   CA0_b   CA_PIN   1.842  2.812nH  1.314pF
P3   VSS   GND
P4   CKE0_b   CKE_PIN   1.453  2.247nH  1.185pF
P5   CKE1_b   CKE_PIN   1.714  2.795nH  1.222pF
P8   CK_t_b   CLK_PIN   2.020  2.840nH  1.279pF
P9   CK_c_b   CLK_PIN   2.093  2.824nH  1.308pF
P10   VSS   GND
P11   CA5_b   CA_PIN   1.953  2.816nH  1.346pF
P12   VSS   GND
R1   VDD2   POWER
R2   CA1_b   CA_PIN   1.851  2.858nH  1.308pF
R3   CS1_b   CS_PIN   1.696  2.737nH  1.191pF
R4   CS0_b   CS_PIN   1.508  2.382nH  1.234pF
R5   VDD2   POWER
R8   VDD2   POWER
R9   CA2_b   CA_PIN   1.684  2.601nH  1.204pF
R10   CA3_b   CA_PIN   1.786  2.725nH  1.282pF
R11   CA4_b   CA_PIN   1.942  2.768nH  1.337pF
R12   VDD2   POWER
T1   VSS   GND
T2   ODT_CA_b   CKE_PIN   1.342  2.239nH  1.109pF
T3   VSS   GND
T4   VDD1   POWER
T5   VSS   GND
T8   VSS   GND
T9   VDD1   POWER
T10   VSS   GND
T11   RESET_n   CKE_PIN   4.177  5.148nH  3.790pF
T12   VSS   GND
U1   VDD1   POWER
U2   DQ3_b   DQ_PIN   1.163  1.850nH  0.818pF
U3   VDDQ   POWER
U4   DQ4_b   DQ_PIN   1.158  1.789nH  0.789pF
U5   VDD2   POWER
U8   VDD2   POWER
U9   DQ12_b   DQ_PIN   1.166  1.814nH  0.790pF
U10   VDDQ   POWER
U11   DQ11_b   DQ_PIN   1.232  1.888nH  0.824pF
U12   VDD1   POWER
V1   VSS   GND
V2   DQ2_b   DQ_PIN   1.126  1.818nH  0.776pF
V3   DQS0_c_b   DQ_PIN   1.213  1.933nH  0.831pF
V4   DQ5_b   DQ_PIN   1.121  1.739nH  0.847pF
V5   VSS   GND
V8   VSS   GND
V9   DQ13_b   DQ_PIN   1.129  1.762nH  0.846pF
V10   DQS1_c_b   DQ_PIN   1.231  1.947nH  0.832pF
V11   DQ10_b   DQ_PIN   1.176  1.805nH  0.776pF
V12   VSS   GND
W1   VDDQ   POWER
W2   VSS   GND
W3   DQS0_t_b   DQ_PIN   1.170  1.865nH  0.825pF
W4   VSS   GND
W5   VDDQ   POWER
W8   VDDQ   POWER
W9   VSS   GND
W10   DQS1_t_b   DQ_PIN   1.189  1.884nH  0.831pF
W11   VSS   GND
W12   VDDQ   POWER
Y1   VSS   GND
Y2   DQ1_b   DQ_PIN   1.094  1.732nH  0.772pF
Y3   DMI0_b   DQ_PIN   1.095  1.772nH  0.862pF
Y4   DQ6_b   DQ_PIN   1.046  1.672nH  0.833pF
Y5   VSS   GND
Y8   VSS   GND
Y9   DQ14_b   DQ_PIN   1.079  1.719nH  0.851pF
Y10   DMI1_b   DQ_PIN   1.114  1.855nH  0.817pF
Y11   DQ9_b   DQ_PIN   1.073  1.734nH  0.831pF
Y12   VSS   GND
AA1   DNU   NC
AA2   DQ0_b   DQ_PIN   1.105  1.741nH  0.826pF
AA3   VDDQ   POWER
AA4   DQ7_b   DQ_PIN   1.121  1.737nH  0.804pF
AA5   VDDQ   POWER
AA8   VDDQ   POWER
AA9   DQ15_b   DQ_PIN   1.117  1.751nH  0.848pF
AA10   VDDQ   POWER
AA11   DQ8_b   DQ_PIN   1.155  1.809nH  0.805pF
AA12   DNU   NC
AB1   DNU   NC
AB2   DNU   NC
AB3   VSS   GND
AB4   VDD2   POWER
AB5   VSS   GND
AB8   VSS   GND
AB9   VDD2   POWER
AB10   VSS   GND
AB11   DNU   NC
AB12   DNU   NC
|*****************************  MODEL SELECTOR *********************************
[Model Selector]   CA_PIN
CA_ODT_40OHM   "CA_ODT_40OHM"
CA_ODT_48OHM   "CA_ODT_48OHM"
CA_ODT_60OHM   "CA_ODT_60OHM"
CA_ODT_80OHM   "CA_ODT_80OHM"
CA_ODT_120OHM   "CA_ODT_120OHM"
CA_ODT_240OHM   "CA_ODT_240OHM"
CA_UNTERM   "CA_UNTERM"
CA_ODT_60OHM_06VDDQ   "CA_ODT_60OHM, FOR 06VDDQ MODEL"
CA_ODT_120OHM_06VDDQ   "CA_ODT_120OHM, FOR 06VDDQ MODEL"
[Model Selector]   CLK_PIN
CK_ODT_40OHM   "CK_ODT_40OHM"
CK_ODT_48OHM   "CK_ODT_48OHM"
CK_ODT_60OHM   "CK_ODT_60OHM"
CK_ODT_80OHM   "CK_ODT_80OHM"
CK_ODT_120OHM   "CK_ODT_120OHM"
CK_ODT_240OHM   "CK_ODT_240OHM"
CK_UNTERM   "CK_UNTERM"
CK_ODT_60OHM_06VDDQ   "CK_ODT_60OHM, FOR 06VDDQ MODEL"
CK_ODT_120OHM_06VDDQ   "CK_ODT_120OHM, FOR 06VDDQ MODEL"
[Model Selector]   CS_PIN
CS_ODT_40OHM   "CS_ODT_40OHM"
CS_ODT_48OHM   "CS_ODT_48OHM"
CS_ODT_60OHM   "CS_ODT_60OHM"
CS_ODT_80OHM   "CS_ODT_80OHM"
CS_ODT_120OHM   "CS_ODT_120OHM"
CS_ODT_240OHM   "CS_ODT_240OHM"
CS_UNTERM   "CS_UNTERM"
CS_ODT_60OHM_06VDDQ   "CS_ODT_60OHM, FOR 06VDDQ MODEL"
CS_ODT_120OHM_06VDDQ   "CS_ODT_120OHM, FOR 06VDDQ MODEL"
[Model Selector]   DQ_PIN
DQ_40OHM_34OHM   "SOC_ODT=40ohm, PD=34ohm"
DQ_40OHM_40OHM   "SOC_ODT=40ohm, PD=40ohm"
DQ_40OHM_48OHM   "SOC_ODT=40ohm, PD=48ohm"
DQ_40OHM_60OHM   "SOC_ODT=40ohm, PD=60ohm"
DQ_48OHM_34OHM   "SOC_ODT=48ohm, PD=34ohm"
DQ_48OHM_40OHM   "SOC_ODT=48ohm, PD=40ohm"
DQ_48OHM_48OHM   "SOC_ODT=48ohm, PD=48ohm"
DQ_48OHM_60OHM   "SOC_ODT=48ohm, PD=60ohm"
DQ_60OHM_34OHM   "SOC_ODT=60ohm, PD=34ohm"
DQ_60OHM_40OHM   "SOC_ODT=60ohm, PD=40ohm"
DQ_60OHM_48OHM   "SOC_ODT=60ohm, PD=48ohm"
DQ_60OHM_60OHM   "SOC_ODT=60ohm, PD=60ohm"
DQ_80OHM_80OHM   "SOC_ODT=80ohm, PD=80ohm"
DQ_120OHM_120OHM   "SOC_ODT=120ohm, PD=120ohm"
DQ_240OHM_240OHM   "SOC_ODT=240ohm, PD=240ohm"
DQ_40OHM_34OHM_06VDDQ   "PU=40ohm, PD=34ohm, voh=0.6vddq"
DQ_40OHM_40OHM_06VDDQ   "PU=40ohm, PD=40ohm, voh=0.6vddq"
DQ_40OHM_48OHM_06VDDQ   "PU=40ohm, PD=48ohm, voh=0.6vddq"
DQ_40OHM_60OHM_06VDDQ   "PU=40ohm, PD=60ohm, voh=0.6vddq"
DQ_40OHM_80OHM_06VDDQ   "PU=40ohm, PD=80ohm, voh=0.6vddq"
DQ_40OHM_120OHM_06VDDQ  "PU=40ohm, PD=120ohm, voh=0.6vddq"
DQ_40OHM_240OHM_06VDDQ  "PU=40ohm, PD=240ohm, voh=0.6vddq"
DQ_80OHM_34OHM_06VDDQ   "PU=80ohm, PD=34ohm, voh=0.6vddq"
DQ_80OHM_40OHM_06VDDQ   "PU=80ohm, PD=40ohm, voh=0.6vddq"
DQ_80OHM_48OHM_06VDDQ   "PU=80ohm, PD=48ohm, voh=0.6vddq"
DQ_80OHM_60OHM_06VDDQ   "PU=80ohm, PD=60ohm, voh=0.6vddq"
DQ_80OHM_80OHM_06VDDQ   "PU=80ohm, PD=80ohm, voh=0.6vddq"
DQ_80OHM_120OHM_06VDDQ  "PU=80ohm, PD=120ohm, voh=0.6vddq"
DQ_80OHM_240OHM_06VDDQ  "PU=80ohm, PD=240ohm, voh=0.6vddq"
DQ_40OHM_34OHM_PREEMP_ON   "SOC_ODT=40ohm, PD=34ohm, preemp_on"
DQ_40OHM_40OHM_PREEMP_ON   "SOC_ODT=40ohm, PD=40ohm, preemp_on"
DQ_40OHM_48OHM_PREEMP_ON   "SOC_ODT=40ohm, PD=48ohm, preemp_on"
DQ_40OHM_60OHM_PREEMP_ON   "SOC_ODT=40ohm, PD=60ohm, preemp_on"
DQ_48OHM_34OHM_PREEMP_ON   "SOC_ODT=48ohm, PD=34ohm, preemp_on"
DQ_48OHM_40OHM_PREEMP_ON   "SOC_ODT=48ohm, PD=40ohm, preemp_on"
DQ_48OHM_48OHM_PREEMP_ON   "SOC_ODT=48ohm, PD=48ohm, preemp_on"
DQ_48OHM_60OHM_PREEMP_ON   "SOC_ODT=48ohm, PD=60ohm, preemp_on"
DQ_60OHM_34OHM_PREEMP_ON   "SOC_ODT=60ohm, PD=34ohm, preemp_on"
DQ_60OHM_40OHM_PREEMP_ON   "SOC_ODT=60ohm, PD=40ohm, preemp_on"
DQ_60OHM_48OHM_PREEMP_ON   "SOC_ODT=60ohm, PD=48ohm, preemp_on"
DQ_60OHM_60OHM_PREEMP_ON   "SOC_ODT=60ohm, PD=60ohm, preemp_on"
DQ_80OHM_80OHM_PREEMP_ON   "SOC_ODT=80ohm, PD=80ohm, preemp_on"
DQ_120OHM_120OHM_PREEMP_ON   "SOC_ODT=120ohm, PD=120ohm, preemp_on"
DQ_240OHM_240OHM_PREEMP_ON   "SOC_ODT=240ohm, PD=240ohm, preemp_on"
DQ_40OHM_34OHM_06VDDQ_PREEMP_ON "PU=40ohm, PD=34ohm, voh=0.6vddq, preemp_on"
DQ_40OHM_40OHM_06VDDQ_PREEMP_ON "PU=40ohm, PD=40ohm, voh=0.6vddq, preemp_on"
DQ_40OHM_48OHM_06VDDQ_PREEMP_ON "PU=40ohm, PD=48ohm, voh=0.6vddq, preemp_on"
DQ_40OHM_60OHM_06VDDQ_PREEMP_ON "PU=40ohm, PD=60ohm, voh=0.6vddq, preemp_on"
DQ_40OHM_80OHM_06VDDQ_PREEMP_ON "PU=40ohm, PD=80ohm, voh=0.6vddq, preemp_on"
DQ_40OHM_120OHM_06VDDQ_PREEMP_ON   "PU=40ohm, PD=120ohm, voh=0.6vddq, preemp_on"
DQ_40OHM_240OHM_06VDDQ_PREEMP_ON   "PU=40ohm, PD=240ohm, voh=0.6vddq, preemp_on"
DQ_80OHM_34OHM_06VDDQ_PREEMP_ON "PU=80ohm, PD=34ohm, voh=0.6vddq, preemp_on"
DQ_80OHM_40OHM_06VDDQ_PREEMP_ON "PU=80ohm, PD=40ohm, voh=0.6vddq, preemp_on"
DQ_80OHM_48OHM_06VDDQ_PREEMP_ON "PU=80ohm, PD=48ohm, voh=0.6vddq, preemp_on"
DQ_80OHM_60OHM_06VDDQ_PREEMP_ON "PU=80ohm, PD=60ohm, voh=0.6vddq, preemp_on"
DQ_80OHM_80OHM_06VDDQ_PREEMP_ON "PU=80ohm, PD=80ohm, voh=0.6vddq, preemp_on"
DQ_80OHM_120OHM_06VDDQ_PREEMP_ON   "PU=80ohm, PD=120ohm, voh=0.6vddq, preemp_on"
DQ_80OHM_240OHM_06VDDQ_PREEMP_ON   "PU=80ohm, PD=240ohm, voh=0.6vddq, preemp_on"
DQ_ODT_40OHM   "DQ_ODT_40OHM"
DQ_ODT_48OHM   "DQ_ODT_48OHM"
DQ_ODT_60OHM   "DQ_ODT_60OHM"
DQ_ODT_80OHM   "DQ_ODT_80OHM"
DQ_ODT_120OHM   "DQ_ODT_120OHM"
DQ_ODT_240OHM   "DQ_ODT_240OHM"
DQ_UNTERM   "DQ_UNTERM"
DQ_ODT_60OHM_06VDDQ   "DQ_ODT_60OHM, voh=0.6vddq"
DQ_ODT_120OHM_06VDDQ   "DQ_ODT_120OHM, voh=0.6vddq"
| Models and submodels in the file (95): CA_ODT_40OHM (Input), CA_ODT_48OHM (Input), CA_ODT_60OHM (Input), CA_ODT_80OHM (Input), CA_ODT_120OHM (Input), CA_ODT_240OHM (Input), CA_UNTERM (Input), CA_ODT_60OHM_06VDDQ (Input), CA_ODT_120OHM_06VDDQ (Input), CK_ODT_40OHM (Input), CK_ODT_48OHM (Input), CK_ODT_60OHM (Input), CK_ODT_80OHM (Input), CK_ODT_120OHM (Input), CK_ODT_240OHM (Input), CK_UNTERM (Input), CK_ODT_60OHM_06VDDQ (Input), CK_ODT_120OHM_06VDDQ (Input), CS_ODT_40OHM (Input), CS_ODT_48OHM (Input), CS_ODT_60OHM (Input), CS_ODT_80OHM (Input), CS_ODT_120OHM (Input), CS_ODT_240OHM (Input), CS_UNTERM (Input), CS_ODT_60OHM_06VDDQ (Input), CS_ODT_120OHM_06VDDQ (Input), DQ_40OHM_34OHM (I/O), DQ_40OHM_40OHM (I/O), DQ_40OHM_48OHM (I/O), DQ_40OHM_60OHM (I/O), DQ_48OHM_34OHM (I/O), DQ_48OHM_40OHM (I/O), DQ_48OHM_48OHM (I/O), DQ_48OHM_60OHM (I/O), DQ_60OHM_34OHM (I/O), DQ_60OHM_40OHM (I/O), DQ_60OHM_48OHM (I/O), DQ_60OHM_60OHM (I/O), DQ_80OHM_80OHM (I/O), DQ_120OHM_120OHM (I/O), DQ_240OHM_240OHM (I/O), DQ_40OHM_34OHM_06VDDQ (I/O), DQ_40OHM_40OHM_06VDDQ (I/O), DQ_40OHM_48OHM_06VDDQ (I/O), DQ_40OHM_60OHM_06VDDQ (I/O), DQ_40OHM_80OHM_06VDDQ (I/O), DQ_40OHM_120OHM_06VDDQ (I/O), DQ_40OHM_240OHM_06VDDQ (I/O), DQ_80OHM_34OHM_06VDDQ (I/O), DQ_80OHM_40OHM_06VDDQ (I/O), DQ_80OHM_48OHM_06VDDQ (I/O), DQ_80OHM_60OHM_06VDDQ (I/O), DQ_80OHM_80OHM_06VDDQ (I/O), DQ_80OHM_120OHM_06VDDQ (I/O), DQ_80OHM_240OHM_06VDDQ (I/O), DQ_40OHM_34OHM_PREEMP_ON (I/O), DQ_40OHM_40OHM_PREEMP_ON (I/O), DQ_40OHM_48OHM_PREEMP_ON (I/O), DQ_40OHM_60OHM_PREEMP_ON (I/O), DQ_48OHM_34OHM_PREEMP_ON (I/O), DQ_48OHM_40OHM_PREEMP_ON (I/O), DQ_48OHM_48OHM_PREEMP_ON (I/O), DQ_48OHM_60OHM_PREEMP_ON (I/O), DQ_60OHM_34OHM_PREEMP_ON (I/O), DQ_60OHM_40OHM_PREEMP_ON (I/O), DQ_60OHM_48OHM_PREEMP_ON (I/O), DQ_60OHM_60OHM_PREEMP_ON (I/O), DQ_80OHM_80OHM_PREEMP_ON (I/O), DQ_120OHM_120OHM_PREEMP_ON (I/O), DQ_240OHM_240OHM_PREEMP_ON (I/O), DQ_40OHM_34OHM_06VDDQ_PREEMP_ON (I/O), DQ_40OHM_40OHM_06VDDQ_PREEMP_ON (I/O), DQ_40OHM_48OHM_06VDDQ_PREEMP_ON (I/O), DQ_40OHM_60OHM_06VDDQ_PREEMP_ON (I/O), DQ_40OHM_80OHM_06VDDQ_PREEMP_ON (I/O), DQ_40OHM_120OHM_06VDDQ_PREEMP_ON (I/O), DQ_40OHM_240OHM_06VDDQ_PREEMP_ON (I/O), DQ_80OHM_34OHM_06VDDQ_PREEMP_ON (I/O), DQ_80OHM_40OHM_06VDDQ_PREEMP_ON (I/O)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
