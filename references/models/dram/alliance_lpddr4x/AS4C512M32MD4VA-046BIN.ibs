[IBIS Ver]   5.0
[File Name]   AS4C512M32MD4VA-046BIN.ibs
[File Rev]   0.0
[Date]   07/29/2025
[Copyright]   Copyright 2015 Alliance Memory Inc. All rights reserved.
[Component]   AS4C512M32MD4VA-046BIN
[Manufacturer] Alliance Memory Inc.
[Package]
| variable   typ   min   max
R_pkg   1.85663   1.39082   9.10363
L_pkg   2.53659nH   2.05809nH   11.2472nH
C_pkg   1.30398pF   1.06755pF   5.00085pF
[Pin]  signal_name  model_name  R_pin   L_pin   C_pin
|DOE   DOE   DUMMY
|DOI   DOI   DUMMY
A3   VSS   GND   NA   NA   NA
A4   VDD2   POWER   0.0592642   0.106867nH   137.717pF
A5   ZQ0   ZQ   9.10363   11.2472nH   5.00085pF
A9   VDD2   POWER   0.0592642   0.106867nH   137.717pF
A10   VSS   GND   NA   NA   NA
B2   DQ0_A   DQ   1.53933   2.30163nH   1.0931pF
B3   VDDQ   POWER   0.0799802   0.144033nH   84.938pF
B4   DQ7_A   DQ   1.58425   2.29352nH   1.17195pF
B5   VDDQ   POWER   0.0799802   0.144033nH   84.938pF
B8   VDDQ   POWER   0.0799802   0.144033nH   84.938pF
B9   DQ15_A   DQ   1.39082   2.05809nH   1.08367pF
B10   VDDQ   POWER   0.0799802   0.144033nH   84.938pF
B11   DQ8_A   DQ   1.48618   2.16778nH   1.10562pF
C1   VSS   GND   NA   NA   NA
C2   DQ1_A   DQ   1.62202   2.29483nH   1.16049pF
C3   DMI0_A   DMI_INPUT   1.54839   2.20291nH   1.19842pF
C4   DQ6_A   DQ   1.45191   2.11566nH   1.10974pF
C5   VSS   GND   NA   NA   NA
C8   VSS   GND   NA   NA   NA
C9   DQ14_A   DQ   1.46285   2.14454nH   1.11726pF
C10   DMI1_A   DMI_INPUT   1.50913   2.16143nH   1.16754pF
C11   DQ9_A   DQ   1.47462   2.12049nH   1.14196pF
C12   VSS   GND   NA   NA   NA
D1   VDDQ   POWER   0.0799802   0.144033nH   84.938pF
D2   VSS   GND   NA   NA   NA
D3   DQS0_t_A   DQS   1.5774   2.2301nH   1.20531pF
D4   VSS   GND   NA   NA   NA
D5   VDDQ   POWER   0.0799802   0.144033nH   84.938pF
D8   VDDQ   POWER   0.0799802   0.144033nH   84.938pF
D9   VSS   GND   NA   NA   NA
D10   DQS1_t_A   DQS   1.57904   2.24573nH   1.22319pF
D11   VSS   GND   NA   NA   NA
D12   VDDQ   POWER   0.0799802   0.144033nH   84.938pF
E1   VSS   GND   NA   NA   NA
E2   DQ2_A   DQ   1.56454   2.16911nH   1.18712pF
E3   DQS0_c_A   DQS   1.58363   2.23783nH   1.23694pF
E4   DQ5_A   DQ   1.54844   2.15395nH   1.11675pF
E5   VSS   GND   NA   NA   NA
E8   VSS   GND   NA   NA   NA
E9   DQ13_A   DQ   1.56706   2.17463nH   1.18492pF
E10   DQS1_c_A   DQS   1.58252   2.25191nH   1.21891pF
E11   DQ10_A   DQ   1.6817   2.31513nH   1.1729pF
E12   VSS   GND   NA   NA   NA
F1   VDD1   POWER   0.291741   0.383801nH   75.1706pF
F2   DQ3_A   DQ   1.69291   2.39106nH   1.07515pF
F3   VDDQ   POWER   0.0799802   0.144033nH   84.938pF
F4   DQ4_A   DQ   1.53264   2.1304nH   1.13469pF
F5   VDD2   POWER   0.0592642   0.106867nH   137.717pF
F8   VDD2   POWER   0.0592642   0.106867nH   137.717pF
F9   DQ12_A   DQ   1.64006   2.27134nH   1.14039pF
F10   VDDQ   POWER   0.0799802   0.144033nH   84.938pF
F11   DQ11_A   DQ   1.5873   2.19982nH   1.1617pF
F12   VDD1   POWER   0.291741   0.383801nH   75.1706pF
G1   VSS   GND   NA   NA   NA
G3   VSS   GND   NA   NA   NA
G4   VDD1   POWER   0.291741   0.383801nH   75.1706pF
G5   VSS   GND   NA   NA   NA
G8   VSS   GND   NA   NA   NA
G9   VDD1   POWER   0.291741   0.383801nH   75.1706pF
G10   VSS   GND   NA   NA   NA
G12   VSS   GND   NA   NA   NA
H1   VDD2   POWER   0.0592642   0.106867nH   137.717pF
H2   CA0_A   CA_INPUT   2.44206   3.24611nH   1.56739pF
H4   CS0_A   CS_INPUT   2.3887   3.16875nH   1.55818pF
H5   VDD2   POWER   0.0592642   0.106867nH   137.717pF
H8   VDD2   POWER   0.0592642   0.106867nH   137.717pF
H9   CA2_A   CA_INPUT   2.40586   3.18594nH   1.58728pF
H10   CA3_A   CA_INPUT   2.40611   3.20974nH   1.60302pF
H11   CA4_A   CA_INPUT   2.42978   3.24618nH   1.61295pF
H12   VDD2   POWER   0.0592642   0.106867nH   137.717pF
J1   VSS   GND   NA   NA   NA
J2   CA1_A   CA_INPUT   2.41817   3.16008nH   1.55871pF
J3   VSS   GND   NA   NA   NA
J4   CKE0_A   CKE_INPUT   2.39449   3.14603nH   1.57338pF
J8   CK_t_A   CK_INPUT   2.47002   3.26083nH   1.71535pF
J9   CK_c_A   CK_INPUT   2.46912   3.2445nH   1.71624pF
J10   VSS   GND   NA   NA   NA
J11   CA5_A   CA_INPUT   2.48265   3.27291nH   1.59197pF
J12   VSS   GND   NA   NA   NA
K1   VDD2   POWER   0.0592642   0.106867nH   137.717pF
K2   VSS   GND   NA   NA   NA
K3   VDD2   POWER   0.0592642   0.106867nH   137.717pF
K4   VSS   GND   NA   NA   NA
K9   VSS   GND   NA   NA   NA
K10   VDD2   POWER   0.0592642   0.106867nH   137.717pF
K11   VSS   GND   NA   NA   NA
K12   VDD2   POWER   0.0592642   0.106867nH   137.717pF
N1   VDD2   POWER   0.0592642   0.106867nH   137.717pF
N2   VSS   GND   NA   NA   NA
N3   VDD2   POWER   0.0592642   0.106867nH   137.717pF
N4   VSS   GND   NA   NA   NA
N9   VSS   GND   NA   NA   NA
N10   VDD2   POWER   0.0592642   0.106867nH   137.717pF
N11   VSS   GND   NA   NA   NA
N12   VDD2   POWER   0.0592642   0.106867nH   137.717pF
P1   VSS   GND   NA   NA   NA
P2   CA1_B   CA_INPUT   2.5695   3.4113nH   1.6172pF
P3   VSS   GND   NA   NA   NA
P4   CKE0_B   CKE_INPUT   2.30518   3.24088nH   1.53827pF
P8   CK_t_B   CK_INPUT   2.44574   3.27303nH   1.68763pF
P9   CK_c_B   CK_INPUT   2.41984   3.24429nH   1.6671pF
P10   VSS   GND   NA   NA   NA
P11   CA5_B   CA_INPUT   2.4422   3.2686nH   1.56683pF
P12   VSS   GND   NA   NA   NA
R1   VDD2   POWER   0.0592642   0.106867nH   137.717pF
R2   CA0_B   CA_INPUT   2.50544   3.33453nH   1.57094pF
R4   CS0_B   CS_INPUT   2.25028   3.20607nH   1.512pF
R5   VDD2   POWER   0.0592642   0.106867nH   137.717pF
R8   VDD2   POWER   0.0592642   0.106867nH   137.717pF
R9   CA2_B   CA_INPUT   2.42541   3.26588nH   1.62637pF
R10   CA3_B   CA_INPUT   2.46476   3.27166nH   1.64473pF
R11   CA4_B   CA_INPUT   2.37818   3.17631nH   1.58312pF
R12   VDD2   POWER   0.0592642   0.106867nH   137.717pF
T1   VSS   GND   NA   NA   NA
T3   VSS   GND   NA   NA   NA
T4   VDD1   POWER   0.291741   0.383801nH   75.1706pF
T5   VSS   GND   NA   NA   NA
T8   VSS   GND   NA   NA   NA
T9   VDD1   POWER   0.291741   0.383801nH   75.1706pF
T10   VSS   GND   NA   NA   NA
T11   RESET_n   RESET   3.80722   5.22975nH   3.07018pF
T12   VSS   GND   NA   NA   NA
U1   VDD1   POWER   0.291741   0.383801nH   75.1706pF
U2   DQ3_B   DQ   1.77543   2.45398nH   1.21208pF
U3   VDDQ   POWER   0.0799802   0.144033nH   84.938pF
U4   DQ4_B   DQ   1.71988   2.38202nH   1.18558pF
U5   VDD2   POWER   0.0592642   0.106867nH   137.717pF
U8   VDD2   POWER   0.0592642   0.106867nH   137.717pF
U9   DQ12_B   DQ   1.65801   2.3053nH   1.13438pF
U10   VDDQ   POWER   0.0799802   0.144033nH   84.938pF
U11   DQ11_B   DQ   1.76437   2.42453nH   1.18603pF
U12   VDD1   POWER   0.291741   0.383801nH   75.1706pF
V1   VSS   GND   NA   NA   NA
V2   DQ2_B   DQ   1.85663   2.53659nH   1.25118pF
V3   DQS0_c_B   DQS   1.73381   2.42542nH   1.30398pF
V4   DQ5_B   DQ   1.69854   2.36952nH   1.23593pF
V5   VSS   GND   NA   NA   NA
V8   VSS   GND   NA   NA   NA
V9   DQ13_B   DQ   1.81118   2.48334nH   1.24149pF
V10   DQS1_c_B   DQS   1.57322   2.27011nH   1.19512pF
V11   DQ10_B   DQ   1.58824   2.25663nH   1.14937pF
V12   VSS   GND   NA   NA   NA
W1   VDDQ   POWER   0.0799802   0.144033nH   84.938pF
W2   VSS   GND   NA   NA   NA
W3   DQS0_t_B   DQS   1.67365   2.36329nH   1.23922pF
W4   VSS   GND   NA   NA   NA
W5   VDDQ   POWER   0.0799802   0.144033nH   84.938pF
W8   VDDQ   POWER   0.0799802   0.144033nH   84.938pF
W9   VSS   GND   NA   NA   NA
W10   DQS1_t_B   DQS   1.54426   2.22656nH   1.19068pF
W11   VSS   GND   NA   NA   NA
W12   VDDQ   POWER   0.0799802   0.144033nH   84.938pF
Y1   VSS   GND   NA   NA   NA
Y2   DQ1_B   DQ   1.69943   2.36587nH   1.24296pF
Y3   DMI0_B   DMI_INPUT   1.67149   2.38619nH   1.19647pF
Y4   DQ6_B   DQ   1.61042   2.33613nH   1.19111pF
Y5   VSS   GND   NA   NA   NA
Y8   VSS   GND   NA   NA   NA
Y9   DQ14_B   DQ   1.5354   2.24274nH   1.17569pF
Y10   DMI1_B   DMI_INPUT   1.5829   2.28719nH   1.17879pF
Y11   DQ9_B   DQ   1.6668   2.3405nH   1.18185pF
Y12   VSS   GND   NA   NA   NA
AA2   DQ0_B   DQ   1.73907   2.43752nH   1.18056pF
AA3   VDDQ   POWER   0.0799802   0.144033nH   84.938pF
AA4   DQ7_B   DQ   1.55232   2.25373nH   1.17035pF
AA5   VDDQ   POWER   0.0799802   0.144033nH   84.938pF
AA8   VDDQ   POWER   0.0799802   0.144033nH   84.938pF
AA9   DQ15_B   DQ   1.47815   2.23836nH   1.07699pF
AA10   VDDQ   POWER   0.0799802   0.144033nH   84.938pF
AA11   DQ8_B   DQ   1.53318   2.2326nH   1.06755pF
AB3   VSS   GND   NA   NA   NA
AB4   VDD2   POWER   0.0592642   0.106867nH   137.717pF
AB5   VSS   GND   NA   NA   NA
AB8   VSS   GND   NA   NA   NA
AB9   VDD2   POWER   0.0592642   0.106867nH   137.717pF
AB10   VSS   GND   NA   NA   NA
|**********************DIFF PIN*******************************************
[Diff_pin]  inv_pin   vdiff   tdelay_typ   tdelay_min   tdelay_max
F7   G7   0.120V   0ns   NA   NA
M7   N7   0.120V   0ns   NA   NA
H14   J14   0.145V   0ns   NA   NA
|*****************************  MODEL SELECTOR *********************************
[Model Selector]   CA_INPUT
CA_ODT_40OHM   "CA_ODT_40OHM"
CA_ODT_48OHM   "CA_ODT_48OHM"
CA_ODT_60OHM   "CA_ODT_60OHM"
CA_ODT_80OHM   "CA_ODT_80OHM"
CA_ODT_120OHM   "CA_ODT_120OHM"
CA_ODT_240OHM   "CA_ODT_240OHM"
CA_UNTERM   "CA_UNTERM"
CA_ODT_40OHM_06VDDQ 	"CA_ODT_40OHM, FOR 06VDDQ MODEL"
CA_ODT_48OHM_06VDDQ 	"CA_ODT_48OHM, FOR 06VDDQ MODEL"
CA_ODT_80OHM_06VDDQ 	"CA_ODT_80OHM, FOR 06VDDQ MODEL"
CA_ODT_240OHM_06VDDQ	"CA_ODT_240OHM, FOR 06VDDQ MODEL"
CA_ODT_60OHM_06VDDQ 	"CA_ODT_40OHM, FOR 06VDDQ MODEL"
CA_ODT_120OHM_06VDDQ	"CA_ODT_48OHM, FOR 06VDDQ MODEL"
[Model Selector]   CK_INPUT
CK_ODT_40OHM   "CK_ODT_40OHM"
CK_ODT_48OHM   "CK_ODT_48OHM"
CK_ODT_60OHM   "CK_ODT_60OHM"
CK_ODT_80OHM   "CK_ODT_80OHM"
CK_ODT_120OHM   "CK_ODT_120OHM"
CK_ODT_240OHM   "CK_ODT_240OHM"
CK_UNTERM   "CK_UNTERM"
CK_ODT_40OHM_06VDDQ 	"CK_ODT_40OHM, FOR 06VDDQ MODEL"
CK_ODT_48OHM_06VDDQ 	"CK_ODT_48OHM, FOR 06VDDQ MODEL"
CK_ODT_80OHM_06VDDQ 	"CK_ODT_80OHM, FOR 06VDDQ MODEL"
CK_ODT_240OHM_06VDDQ	"CK_ODT_240OHM, FOR 06VDDQ MODEL"
CK_ODT_60OHM_06VDDQ   "CK_ODT_60OHM, FOR 06VDDQ MODEL"
CK_ODT_120OHM_06VDDQ   "CK_ODT_120OHM, FOR 06VDDQ MODEL"
[Model Selector]   CS_INPUT
CS_ODT_40OHM   "CS_ODT_40OHM"
CS_ODT_48OHM   "CS_ODT_48OHM"
CS_ODT_60OHM   "CS_ODT_60OHM"
CS_ODT_80OHM   "CS_ODT_80OHM"
CS_ODT_120OHM   "CS_ODT_120OHM"
CS_ODT_240OHM   "CS_ODT_240OHM"
CS_UNTERM   "CS_UNTERM"
CS_ODT_40OHM_06VDDQ 	"CS_ODT_40OHM, FOR 06VDDQ MODEL"
CS_ODT_48OHM_06VDDQ 	"CS_ODT_48OHM, FOR 06VDDQ MODEL"
CS_ODT_80OHM_06VDDQ 	"CS_ODT_80OHM, FOR 06VDDQ MODEL"
CS_ODT_240OHM_06VDDQ	"CS_ODT_240OHM, FOR 06VDDQ MODEL"
CS_ODT_60OHM_06VDDQ   "CS_ODT_60OHM, FOR 06VDDQ MODEL"
CS_ODT_120OHM_06VDDQ   "CS_ODT_120OHM, FOR 06VDDQ MODEL"
[Model Selector]   DQ
DQ_40OHM_34OHM   "SOC_ODT=40ohm, PD=34ohm"
DQ_40OHM_40OHM   "SOC_ODT=40ohm, PD=40ohm"
DQ_40OHM_48OHM   "SOC_ODT=40ohm, PD=48ohm"
DQ_40OHM_60OHM   "SOC_ODT=40ohm, PD=60ohm"
DQ_48OHM_34OHM   "SOC_ODT=48ohm, PD=34ohm"
DQ_48OHM_40OHM   "SOC_ODT=48ohm, PD=40ohm"
DQ_48OHM_48OHM   "SOC_ODT=48ohm, PD=48ohm"
DQ_48OHM_60OHM   "SOC_ODT=48ohm, PD=60ohm"
DQ_60OHM_34OHM   "SOC_ODT=60ohm, PD=34ohm"
DQ_60OHM_40OHM   "SOC_ODT=60ohm, PD=40ohm"
DQ_60OHM_48OHM   "SOC_ODT=60ohm, PD=48ohm"
DQ_60OHM_60OHM   "SOC_ODT=60ohm, PD=60ohm"
DQ_80OHM_80OHM   "SOC_ODT=80ohm, PD=80ohm"
DQ_120OHM_120OHM   "SOC_ODT=120ohm, PD=120ohm"
DQ_240OHM_240OHM   "SOC_ODT=240ohm, PD=240ohm"
DQ_40OHM_34OHM_06VDDQ	"PU=40ohm, PD=34ohm, voh=0.6vddq"
DQ_40OHM_40OHM_06VDDQ	"PU=40ohm, PD=40ohm, voh=0.6vddq"
DQ_40OHM_48OHM_06VDDQ	"PU=40ohm, PD=48ohm, voh=0.6vddq"
DQ_40OHM_60OHM_06VDDQ	"PU=40ohm, PD=60ohm, voh=0.6vddq"
DQ_40OHM_80OHM_06VDDQ	"PU=40ohm, PD=80ohm, voh=0.6vddq"
DQ_40OHM_120OHM_06VDDQ	"PU=40ohm, PD=120ohm, voh=0.6vddq"
DQ_40OHM_240OHM_06VDDQ	"PU=40ohm, PD=240ohm, voh=0.6vddq"
DQ_80OHM_34OHM_06VDDQ	"PU=80ohm, PD=34ohm, voh=0.6vddq"
DQ_80OHM_40OHM_06VDDQ	"PU=80ohm, PD=40ohm, voh=0.6vddq"
DQ_80OHM_48OHM_06VDDQ	"PU=80ohm, PD=48ohm, voh=0.6vddq"
DQ_80OHM_60OHM_06VDDQ	"PU=80ohm, PD=60ohm, voh=0.6vddq"
DQ_80OHM_80OHM_06VDDQ	"PU=80ohm, PD=80ohm, voh=0.6vddq"
DQ_80OHM_120OHM_06VDDQ	"PU=80ohm, PD=120ohm, voh=0.6vddq"
DQ_80OHM_240OHM_06VDDQ	"PU=80ohm, PD=240ohm, voh=0.6vddq"
DQ_40OHM_34OHM_PREEMP_ON	"SOC_ODT=40ohm, PD=34ohm, preemp_on"
DQ_40OHM_40OHM_PREEMP_ON	"SOC_ODT=40ohm, PD=40ohm, preemp_on"
DQ_40OHM_48OHM_PREEMP_ON	"SOC_ODT=40ohm, PD=48ohm, preemp_on"
DQ_40OHM_60OHM_PREEMP_ON	"SOC_ODT=40ohm, PD=60ohm, preemp_on"
DQ_48OHM_34OHM_PREEMP_ON	"SOC_ODT=48ohm, PD=34ohm, preemp_on"
DQ_48OHM_40OHM_PREEMP_ON	"SOC_ODT=48ohm, PD=40ohm, preemp_on"
DQ_48OHM_48OHM_PREEMP_ON	"SOC_ODT=48ohm, PD=48ohm, preemp_on"
DQ_48OHM_60OHM_PREEMP_ON	"SOC_ODT=48ohm, PD=60ohm, preemp_on"
DQ_60OHM_34OHM_PREEMP_ON	"SOC_ODT=60ohm, PD=34ohm, preemp_on"
DQ_60OHM_40OHM_PREEMP_ON	"SOC_ODT=60ohm, PD=40ohm, preemp_on"
DQ_60OHM_48OHM_PREEMP_ON	"SOC_ODT=60ohm, PD=48ohm, preemp_on"
DQ_60OHM_60OHM_PREEMP_ON	"SOC_ODT=60ohm, PD=60ohm, preemp_on"
DQ_80OHM_80OHM_PREEMP_ON	"SOC_ODT=80ohm, PD=80ohm, preemp_on"
DQ_120OHM_120OHM_PREEMP_ON	"SOC_ODT=120ohm, PD=120ohm, preemp_on"
DQ_240OHM_240OHM_PREEMP_ON	"SOC_ODT=240ohm, PD=240ohm, preemp_on"
DQ_40OHM_34OHM_06VDDQ_PREEMP_ON	"PU=40ohm, PD=34ohm, voh=0.6vddq, preemp_on"
DQ_40OHM_40OHM_06VDDQ_PREEMP_ON	"PU=40ohm, PD=40ohm, voh=0.6vddq, preemp_on"
DQ_40OHM_48OHM_06VDDQ_PREEMP_ON	"PU=40ohm, PD=48ohm, voh=0.6vddq, preemp_on"
DQ_40OHM_60OHM_06VDDQ_PREEMP_ON	"PU=40ohm, PD=60ohm, voh=0.6vddq, preemp_on"
DQ_40OHM_80OHM_06VDDQ_PREEMP_ON	"PU=40ohm, PD=80ohm, voh=0.6vddq, preemp_on"
DQ_40OHM_120OHM_06VDDQ_PREEMP_ON	"PU=40ohm, PD=120ohm, voh=0.6vddq, preemp_on"
DQ_40OHM_240OHM_06VDDQ_PREEMP_ON	"PU=40ohm, PD=240ohm, voh=0.6vddq, preemp_on"
DQ_80OHM_34OHM_06VDDQ_PREEMP_ON	"PU=80ohm, PD=34ohm, voh=0.6vddq, preemp_on"
DQ_80OHM_40OHM_06VDDQ_PREEMP_ON	"PU=80ohm, PD=40ohm, voh=0.6vddq, preemp_on"
DQ_80OHM_48OHM_06VDDQ_PREEMP_ON	"PU=80ohm, PD=48ohm, voh=0.6vddq, preemp_on"
DQ_80OHM_60OHM_06VDDQ_PREEMP_ON	"PU=80ohm, PD=60ohm, voh=0.6vddq, preemp_on"
DQ_80OHM_80OHM_06VDDQ_PREEMP_ON	"PU=80ohm, PD=80ohm, voh=0.6vddq, preemp_on"
DQ_80OHM_120OHM_06VDDQ_PREEMP_ON	"PU=80ohm, PD=120ohm, voh=0.6vddq, preemp_on"
DQ_80OHM_240OHM_06VDDQ_PREEMP_ON	"PU=80ohm, PD=240ohm, voh=0.6vddq, preemp_on"
DQ_ODT_40OHM   "DQ_ODT_40OHM"
DQ_ODT_48OHM   "DQ_ODT_48OHM"
DQ_ODT_60OHM   "DQ_ODT_60OHM"
DQ_ODT_80OHM   "DQ_ODT_80OHM"
DQ_ODT_120OHM   "DQ_ODT_120OHM"
DQ_ODT_240OHM   "DQ_ODT_240OHM"
DQ_UNTERM   "DQ_UNTERM"
DQ_ODT_40OHM_06VDDQ 	"DQ_ODT_40OHM, voh=0.6vddq"
DQ_ODT_48OHM_06VDDQ 	"DQ_ODT_48OHM, voh=0.6vddq"
DQ_ODT_80OHM_06VDDQ 	"DQ_ODT_80OHM, voh=0.6vddq"
DQ_ODT_240OHM_06VDDQ	"DQ_ODT_240OHM, voh=0.6vddq"
DQ_ODT_60OHM_06VDDQ 	"DQ_ODT_60OHM, voh=0.6vddq"
DQ_ODT_120OHM_06VDDQ	"DQ_ODT_120OHM, voh=0.6vddq"
| Models and submodels in the file (111): CA_ODT_40OHM (Input), CA_ODT_48OHM (Input), CA_ODT_60OHM (Input), CA_ODT_80OHM (Input), CA_ODT_120OHM (Input), CA_ODT_240OHM (Input), CA_UNTERM (Input), CA_ODT_40OHM_06VDDQ (Input), CA_ODT_48OHM_06VDDQ (Input), CA_ODT_80OHM_06VDDQ (Input), CA_ODT_240OHM_06VDDQ (Input), CA_ODT_60OHM_06VDDQ (Input), CA_ODT_120OHM_06VDDQ (Input), CK_ODT_40OHM (Input), CK_ODT_48OHM (Input), CK_ODT_60OHM (Input), CK_ODT_80OHM (Input), CK_ODT_120OHM (Input), CK_ODT_240OHM (Input), CK_UNTERM (Input), CK_ODT_40OHM_06VDDQ (Input), CK_ODT_48OHM_06VDDQ (Input), CK_ODT_80OHM_06VDDQ (Input), CK_ODT_240OHM_06VDDQ (Input), CK_ODT_60OHM_06VDDQ (Input), CK_ODT_120OHM_06VDDQ (Input), CS_ODT_40OHM (Input), CS_ODT_48OHM (Input), CS_ODT_60OHM (Input), CS_ODT_80OHM (Input), CS_ODT_120OHM (Input), CS_ODT_240OHM (Input), CS_UNTERM (Input), CS_ODT_40OHM_06VDDQ (Input), CS_ODT_48OHM_06VDDQ (Input), CS_ODT_80OHM_06VDDQ (Input), CS_ODT_240OHM_06VDDQ (Input), CS_ODT_60OHM_06VDDQ (Input), CS_ODT_120OHM_06VDDQ (Input), DQ_40OHM_34OHM (I/O), DQ_40OHM_40OHM (I/O), DQ_40OHM_48OHM (I/O), DQ_40OHM_60OHM (I/O), DQ_48OHM_34OHM (I/O), DQ_48OHM_40OHM (I/O), DQ_48OHM_48OHM (I/O), DQ_48OHM_60OHM (I/O), DQ_60OHM_34OHM (I/O), DQ_60OHM_40OHM (I/O), DQ_60OHM_48OHM (I/O), DQ_60OHM_60OHM (I/O), DQ_80OHM_80OHM (I/O), DQ_120OHM_120OHM (I/O), DQ_240OHM_240OHM (I/O), DQ_40OHM_34OHM_06VDDQ (I/O), DQ_40OHM_40OHM_06VDDQ (I/O), DQ_40OHM_48OHM_06VDDQ (I/O), DQ_40OHM_60OHM_06VDDQ (I/O), DQ_40OHM_80OHM_06VDDQ (I/O), DQ_40OHM_120OHM_06VDDQ (I/O), DQ_40OHM_240OHM_06VDDQ (I/O), DQ_80OHM_34OHM_06VDDQ (I/O), DQ_80OHM_40OHM_06VDDQ (I/O), DQ_80OHM_48OHM_06VDDQ (I/O), DQ_80OHM_60OHM_06VDDQ (I/O), DQ_80OHM_80OHM_06VDDQ (I/O), DQ_80OHM_120OHM_06VDDQ (I/O), DQ_80OHM_240OHM_06VDDQ (I/O), DQ_40OHM_34OHM_PREEMP_ON (I/O), DQ_40OHM_40OHM_PREEMP_ON (I/O), DQ_40OHM_48OHM_PREEMP_ON (I/O), DQ_40OHM_60OHM_PREEMP_ON (I/O), DQ_48OHM_34OHM_PREEMP_ON (I/O), DQ_48OHM_40OHM_PREEMP_ON (I/O), DQ_48OHM_48OHM_PREEMP_ON (I/O), DQ_48OHM_60OHM_PREEMP_ON (I/O), DQ_60OHM_34OHM_PREEMP_ON (I/O), DQ_60OHM_40OHM_PREEMP_ON (I/O), DQ_60OHM_48OHM_PREEMP_ON (I/O), DQ_60OHM_60OHM_PREEMP_ON (I/O)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
