[IBIS Ver]   5.0
[File Name]   as4c512m32md4v-046bin.ibs
[File Rev]   1.0
[Date]   2024-04-03
[Source]   File originated from Alliance Memory Inc
   The Following information corresponds to the
   16Gb LPDDR4X 2ch. X32 Die.
[Notes]   Rev 1.0 : 03, Apr. 2024
   File checked by IBISCHK7 V7.2.0.
   While ibischk may report monotonicity warnings,
   the non-monotonic points are not in the "active region"
   of the device.
[Disclaimer] This IBIS model provided "as is" with no warranty and AM
                is not responsible for any problems this model may cause to
                the customers. Customers may only modify the IBIS model to
                fit their particular application.
[Copyright]   Copyright 2024. Alliance Memory Inc. All rights reserved.
[Component]   AS4C512M32MD4V-046BIN
[Manufacturer]  Alliance Memory Inc.
[Package]   |200-BALL FBGA (10.0 X 15.0 X 1.0)
|   typ   min   max
R_pkg   1.207Ohm   0.881Ohm   3.574Ohm
L_pkg   1.762nH   1.333nH   4.058nH
C_pkg   0.974pF   0.734pF   3.803pF
[Pin] signal_name model_name R_pin L_pin C_pin
A1   DNU   NC
A2   DNU   NC
A3   VSS   GND
A4   VDD2   POWER
A5   ZQ0   NC
A8   NC   NC
A9   VDD2   POWER
A10   VSS   GND
A11   DNU   NC
A12   DNU   NC
B1   DNU   NC
B2   DQ0_a   DQ_PIN   0.968  1.465nH  0.780pF
B3   VDDQ   POWER
B4   DQ7_a   DQ_PIN   0.960  1.422nH  0.801pF
B5   VDDQ   POWER
B8   VDDQ   POWER
B9   DQ15_a   DQ_PIN   0.977  1.442nH  0.767pF
B10   VDDQ   POWER
B11   DQ8_a   DQ_PIN   0.907  1.433nH  0.778pF
B12   DNU   NC
C1   VSS   GND
C2   DQ1_a   DQ_PIN   0.919  1.433nH  0.803pF
C3   DMI0_a   DQ_PIN   0.952  1.519nH  0.770pF
C4   DQ6_a   DQ_PIN   0.916  1.397nH  0.803pF
C5   VSS   GND
C8   VSS   GND
C9   DQ14_a   DQ_PIN   0.904  1.378nH  0.792pF
C10   DMI1_a   DQ_PIN   0.938  1.465nH  0.816pF
C11   DQ9_a   DQ_PIN   0.906  1.415nH  0.738pF
C12   VSS   GND
D1   VDDQ   POWER
D2   VSS   GND
D3   DQS0_t_a   DQ_PIN   0.952  1.451nH  0.788pF
D4   VSS   GND
D5   VDDQ   POWER
D8   VDDQ   POWER
D9   VSS   GND
D10   DQS1_t_a   DQ_PIN   0.942  1.451nH  0.782pF
D11   VSS   GND
D12   VDDQ   POWER
E1   VSS   GND
E2   DQ2_a   DQ_PIN   0.937  1.403nH  0.750pF
E3   DQS0_c_a   DQ_PIN   0.995  1.506nH  0.790pF
E4   DQ5_a   DQ_PIN   0.888  1.355nH  0.816pF
E5   VSS   GND
E8   VSS   GND
E9   DQ13_a   DQ_PIN   0.881  1.333nH  0.795pF
E10   DQS1_c_a   DQ_PIN   0.984  1.499nH  0.784pF
E11   DQ10_a   DQ_PIN   0.928  1.403nH  0.741pF
E12   VSS   GND
F1   VDD1   POWER
F2   DQ3_a   DQ_PIN   0.989  1.470nH  0.798pF
F3   VDDQ   POWER
F4   DQ4_a   DQ_PIN   0.924  1.397nH  0.760pF
F5   VDD2   POWER
F8   VDD2   POWER
F9   DQ12_a   DQ_PIN   0.920  1.389nH  0.790pF
F10   VDDQ   POWER
F11   DQ11_a   DQ_PIN   0.967  1.450nH  0.778pF
F12   VDD1   POWER
G1   VSS   GND
G2   ODT_CA_a   CKE_PIN   1.648  2.280nH  1.202pF
G3   VSS   GND
G4   VDD1   POWER
G5   VSS   GND
G8   VSS   GND
G9   VDD1   POWER
G10   VSS   GND
G11   NC   NC
G12   VSS   GND
H1   VDD2   POWER
H2   CA0_a   CA_PIN   1.690  2.317nH  1.249pF
H3   NC   NC
H4   CS_a   CS_PIN   1.662  2.311nH  1.222pF
H5   VDD2   POWER
H8   VDD2   POWER
H9   CA2_a   CA_PIN   1.671  2.236nH  1.234pF
H10   CA3_a   CA_PIN   1.657  2.272nH  1.217pF
H11   CA4_a   CA_PIN   1.602  2.241nH  1.248pF
H12   VDD2   POWER
J1   VSS   GND
J2   CA1_a   CA_PIN   1.666  2.257nH  1.226pF
J3   VSS   GND
J4   CKE_a   CKE_PIN   1.520  2.191nH  1.203pF
J5   NC   NC
J8   CK_t_a   CLK_PIN   1.713  2.330nH  1.204pF
J9   CK_c_a   CLK_PIN   1.729  2.272nH  1.226pF
J10   VSS   GND
J11   CA5_a   CA_PIN   1.733  2.354nH  1.250pF
J12   VSS   GND
K1   VDD2   POWER
K2   VSS   GND
K3   VDD2   POWER
K4   VSS   GND
K5   NC   NC
K8   NC   NC
K9   VSS   GND
K10   VDD2   POWER
K11   VSS   GND
K12   VDD2   POWER
N1   VDD2   POWER
N2   VSS   GND
N3   VDD2   POWER
N4   VSS   GND
N5   NC   NC
N8   NC   NC
N9   VSS   GND
N10   VDD2   POWER
N11   VSS   GND
N12   VDD2   POWER
P1   VSS   GND
P2   CA0_b   CA_PIN   1.601  2.399nH  1.280pF
P3   VSS   GND
P4   CKE_b   CKE_PIN   1.480  2.304nH  1.190pF
P5   NC   NC
P8   CK_t_b   CLK_PIN   1.781  2.416nH  1.250pF
P9   CK_c_b   CLK_PIN   1.854  2.413nH  1.276pF
P10   VSS   GND
P11   CA5_b   CA_PIN   1.713  2.381nH  1.318pF
P12   VSS   GND
R1   VDD2   POWER
R2   CA1_b   CA_PIN   1.611  2.433nH  1.278pF
R3   NC   NC
R4   CS_b   CS_PIN   1.533  2.441nH  1.234pF
R5   VDD2   POWER
R8   VDD2   POWER
R9   CA2_b   CA_PIN   1.445  2.180nH  1.173pF
R10   CA3_b   CA_PIN   1.549  2.305nH  1.248pF
R11   CA4_b   CA_PIN   1.704  2.341nH  1.306pF
R12   VDD2   POWER
T1   VSS   GND
T2   ODT_CA_b   CKE_PIN   1.356  2.319nH  1.113pF
T3   VSS   GND
T4   VDD1   POWER
T5   VSS   GND
T8   VSS   GND
T9   VDD1   POWER
T10   VSS   GND
T11   RESET_n   CKE_PIN   3.574  4.058nH  3.803pF
T12   VSS   GND
U1   VDD1   POWER
U2   DQ3_b   DQ_PIN   0.964  1.446nH  0.771pF
U3   VDDQ   POWER
U4   DQ4_b   DQ_PIN   0.921  1.389nH  0.752pF
U5   VDD2   POWER
U8   VDD2   POWER
U9   DQ12_b   DQ_PIN   0.923  1.397nH  0.755pF
U10   VDDQ   POWER
U11   DQ11_b   DQ_PIN   0.990  1.475nH  0.794pF
U12   VDD1   POWER
V1   VSS   GND
V2   DQ2_b   DQ_PIN   0.923  1.396nH  0.734pF
V3   DQS0_c_b   DQ_PIN   0.982  1.499nH  0.779pF
V4   DQ5_b   DQ_PIN   0.891  1.345nH  0.797pF
V5   VSS   GND
V8   VSS   GND
V9   DQ13_b   DQ_PIN   0.889  1.354nH  0.812pF
V10   DQS1_c_b   DQ_PIN   0.997  1.510nH  0.786pF
V11   DQ10_b   DQ_PIN   0.937  1.404nH  0.745pF
V12   VSS   GND
W1   VDDQ   POWER
W2   VSS   GND
W3   DQS0_t_b   DQ_PIN   0.940  1.450nH  0.776pF
W4   VSS   GND
W5   VDDQ   POWER
W8   VDDQ   POWER
W9   VSS   GND
W10   DQS1_t_b   DQ_PIN   0.954  1.454nH  0.785pF
W11   VSS   GND
W12   VDDQ   POWER
Y1   VSS   GND
Y2   DQ1_b   DQ_PIN   0.906  1.414nH  0.734pF
Y3   DMI0_b   DQ_PIN   0.939  1.464nH  0.812pF
Y4   DQ6_b   DQ_PIN   0.899  1.374nH  0.784pF
Y5   VSS   GND
Y8   VSS   GND
Y9   DQ14_b   DQ_PIN   0.921  1.403nH  0.801pF
Y10   DMI1_b   DQ_PIN   0.957  1.528nH  0.767pF
Y11   DQ9_b   DQ_PIN   0.918  1.433nH  0.798pF
Y12   VSS   GND
AA1   DNU   NC
AA2   DQ0_b   DQ_PIN   0.910  1.438nH  0.775pF
AA3   VDDQ   POWER
AA4   DQ7_b   DQ_PIN   0.970  1.435nH  0.760pF
AA5   VDDQ   POWER
AA8   VDDQ   POWER
AA9   DQ15_b   DQ_PIN   0.962  1.424nH  0.799pF
AA10   VDDQ   POWER
AA11   DQ8_b   DQ_PIN   0.999  1.501nH  0.755pF
AA12   DNU   NC
AB1   DNU   NC
AB2   DNU   NC
AB3   VSS   GND
AB4   VDD2   POWER
AB5   VSS   GND
AB8   VSS   GND
AB9   VDD2   POWER
AB10   VSS   GND
AB11   DNU   NC
AB12   DNU   NC
|*****************************  MODEL SELECTOR *********************************
[Model Selector]   CA_PIN
CA_ODT_40OHM   "CA_ODT_40OHM"
CA_ODT_48OHM   "CA_ODT_48OHM"
CA_ODT_60OHM   "CA_ODT_60OHM"
CA_ODT_80OHM   "CA_ODT_80OHM"
CA_ODT_120OHM   "CA_ODT_120OHM"
CA_ODT_240OHM   "CA_ODT_240OHM"
CA_UNTERM   "CA_UNTERM"
CA_ODT_60OHM_06VDDQ   "CA_ODT_60OHM, FOR 06VDDQ MODEL"
CA_ODT_120OHM_06VDDQ   "CA_ODT_120OHM, FOR 06VDDQ MODEL"
[Model Selector]   CLK_PIN
CK_ODT_40OHM   "CK_ODT_40OHM"
CK_ODT_48OHM   "CK_ODT_48OHM"
CK_ODT_60OHM   "CK_ODT_60OHM"
CK_ODT_80OHM   "CK_ODT_80OHM"
CK_ODT_120OHM   "CK_ODT_120OHM"
CK_ODT_240OHM   "CK_ODT_240OHM"
CK_UNTERM   "CK_UNTERM"
CK_ODT_60OHM_06VDDQ   "CK_ODT_60OHM, FOR 06VDDQ MODEL"
CK_ODT_120OHM_06VDDQ   "CK_ODT_120OHM, FOR 06VDDQ MODEL"
[Model Selector]   CS_PIN
CS_ODT_40OHM   "CS_ODT_40OHM"
CS_ODT_48OHM   "CS_ODT_48OHM"
CS_ODT_60OHM   "CS_ODT_60OHM"
CS_ODT_80OHM   "CS_ODT_80OHM"
CS_ODT_120OHM   "CS_ODT_120OHM"
CS_ODT_240OHM   "CS_ODT_240OHM"
CS_UNTERM   "CS_UNTERM"
CS_ODT_60OHM_06VDDQ   "CS_ODT_60OHM, FOR 06VDDQ MODEL"
CS_ODT_120OHM_06VDDQ   "CS_ODT_120OHM, FOR 06VDDQ MODEL"
[Model Selector]   DQ_PIN
DQ_40OHM_34OHM   "SOC_ODT=40ohm, PD=34ohm"
DQ_40OHM_40OHM   "SOC_ODT=40ohm, PD=40ohm"
DQ_40OHM_48OHM   "SOC_ODT=40ohm, PD=48ohm"
DQ_40OHM_60OHM   "SOC_ODT=40ohm, PD=60ohm"
DQ_48OHM_34OHM   "SOC_ODT=48ohm, PD=34ohm"
DQ_48OHM_40OHM   "SOC_ODT=48ohm, PD=40ohm"
DQ_48OHM_48OHM   "SOC_ODT=48ohm, PD=48ohm"
DQ_48OHM_60OHM   "SOC_ODT=48ohm, PD=60ohm"
DQ_60OHM_34OHM   "SOC_ODT=60ohm, PD=34ohm"
DQ_60OHM_40OHM   "SOC_ODT=60ohm, PD=40ohm"
DQ_60OHM_48OHM   "SOC_ODT=60ohm, PD=48ohm"
DQ_60OHM_60OHM   "SOC_ODT=60ohm, PD=60ohm"
DQ_80OHM_80OHM   "SOC_ODT=80ohm, PD=80ohm"
DQ_120OHM_120OHM   "SOC_ODT=120ohm, PD=120ohm"
DQ_240OHM_240OHM   "SOC_ODT=240ohm, PD=240ohm"
DQ_40OHM_34OHM_06VDDQ   "PU=40ohm, PD=34ohm, voh=0.6vddq"
DQ_40OHM_40OHM_06VDDQ   "PU=40ohm, PD=40ohm, voh=0.6vddq"
DQ_40OHM_48OHM_06VDDQ   "PU=40ohm, PD=48ohm, voh=0.6vddq"
DQ_40OHM_60OHM_06VDDQ   "PU=40ohm, PD=60ohm, voh=0.6vddq"
DQ_40OHM_80OHM_06VDDQ   "PU=40ohm, PD=80ohm, voh=0.6vddq"
DQ_40OHM_120OHM_06VDDQ  "PU=40ohm, PD=120ohm, voh=0.6vddq"
DQ_40OHM_240OHM_06VDDQ  "PU=40ohm, PD=240ohm, voh=0.6vddq"
DQ_80OHM_34OHM_06VDDQ   "PU=80ohm, PD=34ohm, voh=0.6vddq"
DQ_80OHM_40OHM_06VDDQ   "PU=80ohm, PD=40ohm, voh=0.6vddq"
DQ_80OHM_48OHM_06VDDQ   "PU=80ohm, PD=48ohm, voh=0.6vddq"
DQ_80OHM_60OHM_06VDDQ   "PU=80ohm, PD=60ohm, voh=0.6vddq"
DQ_80OHM_80OHM_06VDDQ   "PU=80ohm, PD=80ohm, voh=0.6vddq"
DQ_80OHM_120OHM_06VDDQ  "PU=80ohm, PD=120ohm, voh=0.6vddq"
DQ_80OHM_240OHM_06VDDQ  "PU=80ohm, PD=240ohm, voh=0.6vddq"
DQ_40OHM_34OHM_PREEMP_ON   "SOC_ODT=40ohm, PD=34ohm, preemp_on"
DQ_40OHM_40OHM_PREEMP_ON   "SOC_ODT=40ohm, PD=40ohm, preemp_on"
DQ_40OHM_48OHM_PREEMP_ON   "SOC_ODT=40ohm, PD=48ohm, preemp_on"
DQ_40OHM_60OHM_PREEMP_ON   "SOC_ODT=40ohm, PD=60ohm, preemp_on"
DQ_48OHM_34OHM_PREEMP_ON   "SOC_ODT=48ohm, PD=34ohm, preemp_on"
DQ_48OHM_40OHM_PREEMP_ON   "SOC_ODT=48ohm, PD=40ohm, preemp_on"
DQ_48OHM_48OHM_PREEMP_ON   "SOC_ODT=48ohm, PD=48ohm, preemp_on"
DQ_48OHM_60OHM_PREEMP_ON   "SOC_ODT=48ohm, PD=60ohm, preemp_on"
DQ_60OHM_34OHM_PREEMP_ON   "SOC_ODT=60ohm, PD=34ohm, preemp_on"
DQ_60OHM_40OHM_PREEMP_ON   "SOC_ODT=60ohm, PD=40ohm, preemp_on"
DQ_60OHM_48OHM_PREEMP_ON   "SOC_ODT=60ohm, PD=48ohm, preemp_on"
DQ_60OHM_60OHM_PREEMP_ON   "SOC_ODT=60ohm, PD=60ohm, preemp_on"
DQ_80OHM_80OHM_PREEMP_ON   "SOC_ODT=80ohm, PD=80ohm, preemp_on"
DQ_120OHM_120OHM_PREEMP_ON   "SOC_ODT=120ohm, PD=120ohm, preemp_on"
DQ_240OHM_240OHM_PREEMP_ON   "SOC_ODT=240ohm, PD=240ohm, preemp_on"
DQ_40OHM_34OHM_06VDDQ_PREEMP_ON "PU=40ohm, PD=34ohm, voh=0.6vddq, preemp_on"
DQ_40OHM_40OHM_06VDDQ_PREEMP_ON "PU=40ohm, PD=40ohm, voh=0.6vddq, preemp_on"
DQ_40OHM_48OHM_06VDDQ_PREEMP_ON "PU=40ohm, PD=48ohm, voh=0.6vddq, preemp_on"
DQ_40OHM_60OHM_06VDDQ_PREEMP_ON "PU=40ohm, PD=60ohm, voh=0.6vddq, preemp_on"
DQ_40OHM_80OHM_06VDDQ_PREEMP_ON "PU=40ohm, PD=80ohm, voh=0.6vddq, preemp_on"
DQ_40OHM_120OHM_06VDDQ_PREEMP_ON   "PU=40ohm, PD=120ohm, voh=0.6vddq, preemp_on"
DQ_40OHM_240OHM_06VDDQ_PREEMP_ON   "PU=40ohm, PD=240ohm, voh=0.6vddq, preemp_on"
DQ_80OHM_34OHM_06VDDQ_PREEMP_ON "PU=80ohm, PD=34ohm, voh=0.6vddq, preemp_on"
DQ_80OHM_40OHM_06VDDQ_PREEMP_ON "PU=80ohm, PD=40ohm, voh=0.6vddq, preemp_on"
DQ_80OHM_48OHM_06VDDQ_PREEMP_ON "PU=80ohm, PD=48ohm, voh=0.6vddq, preemp_on"
DQ_80OHM_60OHM_06VDDQ_PREEMP_ON "PU=80ohm, PD=60ohm, voh=0.6vddq, preemp_on"
DQ_80OHM_80OHM_06VDDQ_PREEMP_ON "PU=80ohm, PD=80ohm, voh=0.6vddq, preemp_on"
DQ_80OHM_120OHM_06VDDQ_PREEMP_ON   "PU=80ohm, PD=120ohm, voh=0.6vddq, preemp_on"
DQ_80OHM_240OHM_06VDDQ_PREEMP_ON   "PU=80ohm, PD=240ohm, voh=0.6vddq, preemp_on"
DQ_ODT_40OHM   "DQ_ODT_40OHM"
DQ_ODT_48OHM   "DQ_ODT_48OHM"
DQ_ODT_60OHM   "DQ_ODT_60OHM"
DQ_ODT_80OHM   "DQ_ODT_80OHM"
DQ_ODT_120OHM   "DQ_ODT_120OHM"
DQ_ODT_240OHM   "DQ_ODT_240OHM"
DQ_UNTERM   "DQ_UNTERM"
DQ_ODT_60OHM_06VDDQ   "DQ_ODT_60OHM, voh=0.6vddq"
DQ_ODT_120OHM_06VDDQ   "DQ_ODT_120OHM, voh=0.6vddq"
| Models and submodels in the file (95): CA_ODT_40OHM (Input), CA_ODT_48OHM (Input), CA_ODT_60OHM (Input), CA_ODT_80OHM (Input), CA_ODT_120OHM (Input), CA_ODT_240OHM (Input), CA_UNTERM (Input), CA_ODT_60OHM_06VDDQ (Input), CA_ODT_120OHM_06VDDQ (Input), CK_ODT_40OHM (Input), CK_ODT_48OHM (Input), CK_ODT_60OHM (Input), CK_ODT_80OHM (Input), CK_ODT_120OHM (Input), CK_ODT_240OHM (Input), CK_UNTERM (Input), CK_ODT_60OHM_06VDDQ (Input), CK_ODT_120OHM_06VDDQ (Input), CS_ODT_40OHM (Input), CS_ODT_48OHM (Input), CS_ODT_60OHM (Input), CS_ODT_80OHM (Input), CS_ODT_120OHM (Input), CS_ODT_240OHM (Input), CS_UNTERM (Input), CS_ODT_60OHM_06VDDQ (Input), CS_ODT_120OHM_06VDDQ (Input), DQ_40OHM_34OHM (I/O), DQ_40OHM_40OHM (I/O), DQ_40OHM_48OHM (I/O), DQ_40OHM_60OHM (I/O), DQ_48OHM_34OHM (I/O), DQ_48OHM_40OHM (I/O), DQ_48OHM_48OHM (I/O), DQ_48OHM_60OHM (I/O), DQ_60OHM_34OHM (I/O), DQ_60OHM_40OHM (I/O), DQ_60OHM_48OHM (I/O), DQ_60OHM_60OHM (I/O), DQ_80OHM_80OHM (I/O), DQ_120OHM_120OHM (I/O), DQ_240OHM_240OHM (I/O), DQ_40OHM_34OHM_06VDDQ (I/O), DQ_40OHM_40OHM_06VDDQ (I/O), DQ_40OHM_48OHM_06VDDQ (I/O), DQ_40OHM_60OHM_06VDDQ (I/O), DQ_40OHM_80OHM_06VDDQ (I/O), DQ_40OHM_120OHM_06VDDQ (I/O), DQ_40OHM_240OHM_06VDDQ (I/O), DQ_80OHM_34OHM_06VDDQ (I/O), DQ_80OHM_40OHM_06VDDQ (I/O), DQ_80OHM_48OHM_06VDDQ (I/O), DQ_80OHM_60OHM_06VDDQ (I/O), DQ_80OHM_80OHM_06VDDQ (I/O), DQ_80OHM_120OHM_06VDDQ (I/O), DQ_80OHM_240OHM_06VDDQ (I/O), DQ_40OHM_34OHM_PREEMP_ON (I/O), DQ_40OHM_40OHM_PREEMP_ON (I/O), DQ_40OHM_48OHM_PREEMP_ON (I/O), DQ_40OHM_60OHM_PREEMP_ON (I/O), DQ_48OHM_34OHM_PREEMP_ON (I/O), DQ_48OHM_40OHM_PREEMP_ON (I/O), DQ_48OHM_48OHM_PREEMP_ON (I/O), DQ_48OHM_60OHM_PREEMP_ON (I/O), DQ_60OHM_34OHM_PREEMP_ON (I/O), DQ_60OHM_40OHM_PREEMP_ON (I/O), DQ_60OHM_48OHM_PREEMP_ON (I/O), DQ_60OHM_60OHM_PREEMP_ON (I/O), DQ_80OHM_80OHM_PREEMP_ON (I/O), DQ_120OHM_120OHM_PREEMP_ON (I/O), DQ_240OHM_240OHM_PREEMP_ON (I/O), DQ_40OHM_34OHM_06VDDQ_PREEMP_ON (I/O), DQ_40OHM_40OHM_06VDDQ_PREEMP_ON (I/O), DQ_40OHM_48OHM_06VDDQ_PREEMP_ON (I/O), DQ_40OHM_60OHM_06VDDQ_PREEMP_ON (I/O), DQ_40OHM_80OHM_06VDDQ_PREEMP_ON (I/O), DQ_40OHM_120OHM_06VDDQ_PREEMP_ON (I/O), DQ_40OHM_240OHM_06VDDQ_PREEMP_ON (I/O), DQ_80OHM_34OHM_06VDDQ_PREEMP_ON (I/O), DQ_80OHM_40OHM_06VDDQ_PREEMP_ON (I/O)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
