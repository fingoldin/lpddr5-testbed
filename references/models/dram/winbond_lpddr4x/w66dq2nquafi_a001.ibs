| 8Gb LPDDR4x SDRAM
|Part Number   VDD1/VDD2//VDDQ   I/O   Type   Others
|W66DQ2NQUAFI   1.8V/1.1V/0.6V   32   DDP-WFBGA200L   1600MHz, -40C~95C
[IBIS Ver]  5.0
[File Name] w66dq2nquafi_a001.ibs
[File Rev]  001
[Date]   Oct 29, 2019
[Source]   From SPICE model at Winbond Electronics Corp.
[Notes]
   - IBIS Model Revision History:
   Rev 001: First release
[Disclaimer]  This software code and all associated documentation,
   comments or other information (collectively "Software") is
   provided "AS IS" without warranty of any kind. Winbond Electronics
   Corporation ("WEC") hereby DISCLAIMS ALL WARRANTIES EXPRESS
   OR IMPLIED, INCLUDING BUT NOT LIMITED TO, NONINFRINGEMENT
   OF THIRD PARTY RIGHTS, AND ANY IMPLIED WARRANTIES OF MERCHANTABILITY
   OR FITNESS FOR ANY PARTICULAR PURPOSE. WEC DOES NOT
   WARRANT THAT THE SOFTWARE WILL MEET YOUR REQUIREMENTS, OR THAT
   THE OPERATION OF THE SOFTWARE WILL BE UNINTERRUPTED OR ERROR-FREE.
   FURTHERMORE, WEC DOES NOT MAKE ANY REPRESENTATIONS REGARDING
   THE USE OR THE RESULTS OF THE USE OF THE SOFTWARE IN
   TERMS OF ITS CORRECTNESS, ACCURACY, RELIABILITY, OR OTHERWISE.
   THE ENTIRE RISK ARISING OUT OF USE OR PERFORMANCE OF THE SOFTWARE
   SHALL REMAIN WITH YOU. IN NO EVENT SHALL WEC, ITS AFFILIATED
   COMPANIES OR THEIR SUPPLIERS BE LIABLE FOR ANY DIRECT,
   INDIRECT, CONSEQUENTIAL, INCIDENTAL, OR SPECIAL DAMAGES (INCLUDING,
   WITHOUT LIMITATION, DAMAGES FOR LOSS OF PROFITS, BUSINESS
   INTERRUPTION, OR LOSS OF INFORMATION) ARISING OUT OF YOUR
   USE OF OR INABILITY TO USE THE SOFTWARE, EVEN IF WEC HAS BEEN
   ADVISED OF THE POSSIBILITY OF SUCH DAMAGES.
[Copyright] Copyright 2019 Winbond Electronics Corporation. All rights reserved
[Component]  W66DQ2NQUAFI
[Manufacturer] Winbond Electronics Corp.
[Package Model]   W66DQ2NQUAFI DDP 10X14.5 2L 200L
[Package]
| variable   typ  min  max
R_pkg   0   0   0
L_pkg   0   0   0
C_pkg   0   0   0
[Pin] Signal_Name   Model_Name  R_Pin  L_Pin C_Pin
H2   CA0_A   CA
R2   CA0_B   CA
J2   CA1_A   CA
P2   CA1_B   CA
H9   CA2_A   CA
R9   CA2_B   CA
H10   CA3_A   CA
R10   CA3_B   CA
H11   CA4_A   CA
R11   CA4_B   CA
J11   CA5_A   CA
P11   CA5_B   CA
J9   CK_C_A   CLK
P9   CK_C_B   CLK
J8   CK_T_A   CLK
P8   CK_T_B   CLK
J4   CKE0_A   CKE_INPUT
P4   CKE0_B   CKE_INPUT
H4   CS0_A   CS
R4   CS0_B   CS
C3   DMI0_A   I/O
Y3   DMI0_B   I/O
C10   DMI1_A   I/O
Y10   DMI1_B   I/O
B2   DQ0_A   I/O
AA2   DQ0_B   I/O
C2   DQ1_A   I/O
Y2   DQ1_B   I/O
E2   DQ2_A   I/O
V2   DQ2_B   I/O
F2   DQ3_A   I/O
U2   DQ3_B   I/O
F4   DQ4_A   I/O
U4   DQ4_B   I/O
E4   DQ5_A   I/O
V4   DQ5_B   I/O
C4   DQ6_A   I/O
Y4   DQ6_B   I/O
B4   DQ7_A   I/O
AA4   DQ7_B   I/O
B11   DQ8_A   I/O
AA11   DQ8_B   I/O
C11   DQ9_A   I/O
Y11   DQ9_B   I/O
E11   DQ10_A   I/O
V11   DQ10_B   I/O
F11   DQ11_A   I/O
U11   DQ11_B   I/O
F9   DQ12_A   I/O
U9   DQ12_B   I/O
E9   DQ13_A   I/O
V9   DQ13_B   I/O
C9   DQ14_A   I/O
Y9   DQ14_B   I/O
B9   DQ15_A   I/O
AA9   DQ15_B   I/O
V3   DQS0_C_B  I/O
E3   DQS0_C_A  I/O
D3   DQS0_T_A  I/O
W3   DQS0_T_B  I/O
E10   DQS1_C_A  I/O
V10   DQS1_C_B  I/O
D10   DQS1_T_A  I/O
W10   DQS1_T_B  I/O
G2   ODT_CA_A  NC
T2   ODT_CA_B  NC
T11   RESET_N   NC
B1   SEN_A   NC
AA12   SEN_B   NC
A5   ZQ0   NC
G4   VDD1   POWER
H1   VDD2   POWER
D12   VDDQ   POWER
E12   VSS   GND
[Diff Pin]   inv_pin   vdiff   tdelay_typ   tdelay_min   tdelay_max
D3   E3   0.280V   0.000s   NA   NA
W3   V3   0.280V   0.000s   NA   NA
D10   E10   0.280V   0.000s   NA   NA
W10   V10   0.280V   0.000s   NA   NA
J8   J9   0.310V   0.000s   NA   NA
P8   P9   0.310V   0.000s   NA   NA
[Model Selector]   I/O
PD40_ODT40_VOH300   Pulldown driver 40  Ohm,  40 Ohm System ODT,  VOH=VDDQ*0.5
PD48_ODT40_VOH300   Pulldown driver 48  Ohm,  40 Ohm System ODT,  VOH=VDDQ*0.5
PD60_ODT40_VOH300   Pulldown driver 60  Ohm,  40 Ohm System ODT,  VOH=VDDQ*0.5
PD80_ODT40_VOH300   Pulldown driver 80  Ohm,  40 Ohm System ODT,  VOH=VDDQ*0.5
PD120_ODT40_VOH300   Pulldown driver 120 Ohm,  40 Ohm System ODT,  VOH=VDDQ*0.5
PD240_ODT40_VOH300   Pulldown driver 240 Ohm,  40 Ohm System ODT,  VOH=VDDQ*0.5
PD40_ODT48_VOH300   Pulldown driver 40  Ohm,  48 Ohm System ODT,  VOH=VDDQ*0.5
PD48_ODT48_VOH300   Pulldown driver 48  Ohm,  48 Ohm System ODT,  VOH=VDDQ*0.5
PD60_ODT48_VOH300   Pulldown driver 60  Ohm,  48 Ohm System ODT,  VOH=VDDQ*0.5
PD80_ODT48_VOH300   Pulldown driver 80  Ohm,  48 Ohm System ODT,  VOH=VDDQ*0.5
PD120_ODT48_VOH300   Pulldown driver 120 Ohm,  48 Ohm System ODT,  VOH=VDDQ*0.5
PD240_ODT48_VOH300   Pulldown driver 240 Ohm,  48 Ohm System ODT,  VOH=VDDQ*0.5
PD40_ODT60_VOH300   Pulldown driver 40  Ohm,  60 Ohm System ODT,  VOH=VDDQ*0.5
PD48_ODT60_VOH300   Pulldown driver 48  Ohm,  60 Ohm System ODT,  VOH=VDDQ*0.5
PD60_ODT60_VOH300   Pulldown driver 60  Ohm,  60 Ohm System ODT,  VOH=VDDQ*0.5
PD80_ODT60_VOH300   Pulldown driver 80  Ohm,  60 Ohm System ODT,  VOH=VDDQ*0.5
PD120_ODT60_VOH300   Pulldown driver 120 Ohm,  60 Ohm System ODT,  VOH=VDDQ*0.5
PD240_ODT60_VOH300   Pulldown driver 240 Ohm,  60 Ohm System ODT,  VOH=VDDQ*0.5
PD40_ODT80_VOH300   Pulldown driver 40  Ohm,  80 Ohm System ODT,  VOH=VDDQ*0.5
PD48_ODT80_VOH300   Pulldown driver 48  Ohm,  80 Ohm System ODT,  VOH=VDDQ*0.5
PD60_ODT80_VOH300   Pulldown driver 60  Ohm,  80 Ohm System ODT,  VOH=VDDQ*0.5
PD80_ODT80_VOH300   Pulldown driver 80  Ohm,  80 Ohm System ODT,  VOH=VDDQ*0.5
PD120_ODT80_VOH300   Pulldown driver 120 Ohm,  80 Ohm System ODT,  VOH=VDDQ*0.5
PD240_ODT80_VOH300   Pulldown driver 240 Ohm,  80 Ohm System ODT,  VOH=VDDQ*0.5
PD40_ODT120_VOH300   Pulldown driver 40  Ohm,  120 Ohm System ODT, VOH=VDDQ*0.5
PD48_ODT120_VOH300   Pulldown driver 48  Ohm,  120 Ohm System ODT, VOH=VDDQ*0.5
PD60_ODT120_VOH300   Pulldown driver 60  Ohm,  120 Ohm System ODT, VOH=VDDQ*0.5
PD80_ODT120_VOH300   Pulldown driver 80  Ohm,  120 Ohm System ODT, VOH=VDDQ*0.5
PD120_ODT120_VOH300  Pulldown driver 120 Ohm,  120 Ohm System ODT, VOH=VDDQ*0.5
PD240_ODT120_VOH300  Pulldown driver 240 Ohm,  120 Ohm System ODT, VOH=VDDQ*0.5
PD40_ODT240_VOH300   Pulldown driver 40  Ohm,  240 Ohm System ODT, VOH=VDDQ*0.5
PD48_ODT240_VOH300   Pulldown driver 48  Ohm,  240 Ohm System ODT, VOH=VDDQ*0.5
PD60_ODT240_VOH300   Pulldown driver 60  Ohm,  240 Ohm System ODT, VOH=VDDQ*0.5
PD80_ODT240_VOH300   Pulldown driver 80  Ohm,  240 Ohm System ODT, VOH=VDDQ*0.5
PD120_ODT240_VOH300  Pulldown driver 120 Ohm,  240 Ohm System ODT, VOH=VDDQ*0.5
PD240_ODT240_VOH300  Pulldown driver 240 Ohm,  240 Ohm System ODT, VOH=VDDQ*0.5
PD40_ODTDIS_VOH300   Pulldown driver 40  Ohm,  DIS System ODT,   VOH=VDDQ*0.5
PD48_ODTDIS_VOH300   Pulldown driver 48  Ohm,  DIS System ODT,   VOH=VDDQ*0.5
PD60_ODTDIS_VOH300   Pulldown driver 60  Ohm,  DIS System ODT,   VOH=VDDQ*0.5
PD80_ODTDIS_VOH300   Pulldown driver 80  Ohm,  DIS System ODT,   VOH=VDDQ*0.5
PD120_ODTDIS_VOH300  Pulldown driver 120 Ohm,  DIS System ODT,   VOH=VDDQ*0.5
PD240_ODTDIS_VOH300  Pulldown driver 240 Ohm,  DIS System ODT,   VOH=VDDQ*0.5
PD40_ODT60_VOH360   Pulldown driver 40  Ohm,  60 Ohm System ODT,  VOH=VDDQ*0.6
PD48_ODT60_VOH360   Pulldown driver 48  Ohm,  60 Ohm System ODT,  VOH=VDDQ*0.6
PD60_ODT60_VOH360   Pulldown driver 60  Ohm,  60 Ohm System ODT,  VOH=VDDQ*0.6
PD80_ODT60_VOH360   Pulldown driver 80  Ohm,  60 Ohm System ODT,  VOH=VDDQ*0.6
PD120_ODT60_VOH360   Pulldown driver 120 Ohm,  60 Ohm System ODT,  VOH=VDDQ*0.6
PD240_ODT60_VOH360   Pulldown driver 240 Ohm,  60 Ohm System ODT,  VOH=VDDQ*0.6
PD40_ODT120_VOH360   Pulldown driver 40  Ohm,  120 Ohm System ODT, VOH=VDDQ*0.6
PD48_ODT120_VOH360   Pulldown driver 48  Ohm,  120 Ohm System ODT, VOH=VDDQ*0.6
PD60_ODT120_VOH360   Pulldown driver 60  Ohm,  120 Ohm System ODT, VOH=VDDQ*0.6
PD80_ODT120_VOH360   Pulldown driver 80  Ohm,  120 Ohm System ODT, VOH=VDDQ*0.6
PD120_ODT120_VOH360  Pulldown driver 120 Ohm,  120 Ohm System ODT, VOH=VDDQ*0.6
PD240_ODT120_VOH360  Pulldown driver 240 Ohm,  120 Ohm System ODT, VOH=VDDQ*0.6
PD40_ODTDIS_VOH360   Pulldown driver 40  Ohm,  DIS System ODT,   VOH=VDDQ*0.6
PD48_ODTDIS_VOH360   Pulldown driver 48  Ohm,  DIS System ODT,   VOH=VDDQ*0.6
PD60_ODTDIS_VOH360   Pulldown driver 60  Ohm,  DIS System ODT,   VOH=VDDQ*0.6
PD80_ODTDIS_VOH360   Pulldown driver 80  Ohm,  DIS System ODT,   VOH=VDDQ*0.6
PD120_ODTDIS_VOH360  Pulldown driver 120 Ohm,  DIS System ODT,   VOH=VDDQ*0.6
PD240_ODTDIS_VOH360  Pulldown driver 240 Ohm,  DIS System ODT,   VOH=VDDQ*0.6
ODT_OFF   ODT OFF
ODT_40   ODT 40  Ohm
ODT_48   ODT 48  Ohm
ODT_60   ODT 60  Ohm
ODT_80   ODT 80  Ohm
ODT_120   ODT 120 Ohm
ODT_240   ODT 240 Ohm
[Model Selector]   CA
CA_INPUT   ODT OFF
CA_ODT40   ODT 40  Ohm
CA_ODT48   ODT 48  Ohm
CA_ODT60   ODT 60  Ohm
CA_ODT80   ODT 80  Ohm
CA_ODT120   ODT 120 Ohm
CA_ODT240   ODT 240 Ohm
[Model Selector]   CS
CS_INPUT   ODT OFF
CS_ODT40   ODT 40  Ohm
CS_ODT48   ODT 48  Ohm
CS_ODT60   ODT 60  Ohm
CS_ODT80   ODT 80  Ohm
CS_ODT120   ODT 120 Ohm
CS_ODT240   ODT 240 Ohm
[Model Selector]   CLK
CLK_INPUT   ODT OFF
CLK_ODT40   ODT 40  Ohm
CLK_ODT48   ODT 48  Ohm
CLK_ODT60   ODT 60  Ohm
CLK_ODT80   ODT 80  Ohm
CLK_ODT120   ODT 120 Ohm
CLK_ODT240   ODT 240 Ohm
[Define Package Model]   W66DQ2NQUAFI DDP 10X14.5 2L 200L
[Manufacturer]  Unknown
[OEM]  Unknown
[Description]  None
[Number Of Pins]  74
[Pin Numbers]
|Pin Num   Terminal Name
|1   | CA0_A:Bondwire35_ObjectFromFace1
H2
|2   | CA0_B:Bondwire137_ObjectFromFace1
R2
|3   | CA1_A:Bondwire36_ObjectFromFace1
J2
|4   | CA1_B:Bondwire138_ObjectFromFace1
P2
|5   | CA2_A:Bondwire44_ObjectFromFace1
H9
|6   | CA2_B:Bondwire140_ObjectFromFace1
R9
|7   | CA3_A:Bondwire45_ObjectFromFace1
H10
|8   | CA3_B:Bondwire141_ObjectFromFace1
R10
|9   | CA4_A:Bondwire47_ObjectFromFace1
H11
|10   | CA4_B:Bondwire149_ObjectFromFace1
R11
|11   | CA5_A:Bondwire48_ObjectFromFace1
J11
|12   | CA5_B:Bondwire150_ObjectFromFace1
P11
|13   | CK_C_A:Bondwire42_ObjectFromFace1
J9
|14   | CK_C_B:Bondwire143_ObjectFromFace1
P9
|15   | CK_T_A:Bondwire41_ObjectFromFace1
J8
|16   | CK_T_B:Bondwire144_ObjectFromFace1
P8
|17   | CKE0_A:Bondwire39_ObjectFromFace1
J4
|18   | CKE0_B:Bondwire146_ObjectFromFace1
P4
|19   | CS0_A:Bondwire38_ObjectFromFace1
H4
|20   | CS0_B:Bondwire147_ObjectFromFace1
R4
|21   | DMI0_A:Bondwire20_ObjectFromFace1
C3
|22   | DMI0_B:Bondwire121_ObjectFromFace1
Y3
|23   | DMI1_A:Bondwire64_ObjectFromFace1
C10
|24   | DMI1_B:Bondwire166_ObjectFromFace1
Y10
|25   | DQ0_A:Bondwire6_ObjectFromFace1
B2
|26   | DQ0_B:Bondwire107_ObjectFromFace1
AA2
|27   | DQ1_A:Bondwire8_ObjectFromFace1
C2
|28   | DQ1_B:Bondwire109_ObjectFromFace1
Y2
|29   | DQ2_A:Bondwire10_ObjectFromFace1
E2
|30   | DQ2_B:Bondwire111_ObjectFromFace1
V2
|31   | DQ3_A:Bondwire12_ObjectFromFace1
F2
|32   | DQ3_B:Bondwire113_ObjectFromFace1
U2
|33   | DQ4_A:Bondwire22_ObjectFromFace1
F4
|34   | DQ4_B:Bondwire123_ObjectFromFace1
U4
|35   | DQ5_A:Bondwire24_ObjectFromFace1
E4
|36   | DQ5_B:Bondwire125_ObjectFromFace1
V4
|37   | DQ6_A:Bondwire26_ObjectFromFace1
C4
|38   | DQ6_B:Bondwire127_ObjectFromFace1
Y4
|39   | DQ7_A:Bondwire28_ObjectFromFace1
B4
|40   | DQ7_B:Bondwire129_ObjectFromFace1
AA4
|41   | DQ8_A:Bondwire78_ObjectFromFace1
B11
|42   | DQ8_B:Bondwire180_ObjectFromFace1
AA11
|43   | DQ9_A:Bondwire76_ObjectFromFace1
C11
|44   | DQ9_B:Bondwire178_ObjectFromFace1
Y11
|45   | DQ10_A:Bondwire74_ObjectFromFace1
E11
|46   | DQ10_B:Bondwire176_ObjectFromFace1
V11
|47   | DQ11_A:Bondwire72_ObjectFromFace1
F11
|48   | DQ11_B:Bondwire174_ObjectFromFace1
U11
|49   | DQ12_A:Bondwire62_ObjectFromFace1
F9
|50   | DQ12_B:Bondwire164_ObjectFromFace1
U9
|51   | DQ13_A:Bondwire60_ObjectFromFace1
E9
|52   | DQ13_B:Bondwire162_ObjectFromFace1
V9
|53   | DQ14_A:Bondwire58_ObjectFromFace1
C9
|54   | DQ14_B:Bondwire160_ObjectFromFace1
Y9
|55   | DQ15_A:Bondwire56_ObjectFromFace1
B9
|56   | DQ15_B:Bondwire158_ObjectFromFace1
AA9
|57   | DQS0_C_A:Bondwire18_ObjectFromFace1
E3
|58   | DQS0_C_B:Bondwire119_ObjectFromFace1
V3
|59   | DQS0_T_A:Bondwire17_ObjectFromFace1
D3
|60   | DQS0_T_B:Bondwire118_ObjectFromFace1
W3
|61   | DQS1_C_A:Bondwire66_ObjectFromFace1
E10
|62   | DQS1_C_B:Bondwire168_ObjectFromFace1
V10
|63   | DQS1_T_A:Bondwire67_ObjectFromFace1
D10
|64   | DQS1_T_B:Bondwire169_ObjectFromFace1
W10
|65   | ODT_CA_A:Bondwire33_ObjectFromFace1
G2
|66   | ODT_CA_B:Bondwire152_ObjectFromFace1
T2
|67   | RESET_N:Bondwire51_ObjectFromFace1
T11
|68   | SEN_A:Bondwire85_ObjectFromFace1
B1
|69   | SEN_B:Bondwire100_ObjectFromFace1
AA12
|70   | VDD1:Bondwire2_ObjectFromFace1
G4
|71   | VDD2:Bondwire3_ObjectFromFace1
H1
|72   | VDDQ:Bondwire7_ObjectFromFace1
D12
|73   | VSS:Bondwire1_ObjectFromFace1
E12
|74   | ZQ0:Bondwire54_ObjectFromFace1
A5
[Model Data]
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[End Model Data]
[End Package Model]
| Models and submodels in the file (89): PD40_ODT40_VOH300 (I/O), PD48_ODT40_VOH300 (I/O), PD60_ODT40_VOH300 (I/O), PD80_ODT40_VOH300 (I/O), PD120_ODT40_VOH300 (I/O), PD240_ODT40_VOH300 (I/O), PD40_ODT48_VOH300 (I/O), PD48_ODT48_VOH300 (I/O), PD60_ODT48_VOH300 (I/O), PD80_ODT48_VOH300 (I/O), PD120_ODT48_VOH300 (I/O), PD240_ODT48_VOH300 (I/O), PD40_ODT60_VOH300 (I/O), PD48_ODT60_VOH300 (I/O), PD60_ODT60_VOH300 (I/O), PD80_ODT60_VOH300 (I/O), PD120_ODT60_VOH300 (I/O), PD240_ODT60_VOH300 (I/O), PD40_ODT80_VOH300 (I/O), PD48_ODT80_VOH300 (I/O), PD60_ODT80_VOH300 (I/O), PD80_ODT80_VOH300 (I/O), PD120_ODT80_VOH300 (I/O), PD240_ODT80_VOH300 (I/O), PD40_ODT120_VOH300 (I/O), PD48_ODT120_VOH300 (I/O), PD60_ODT120_VOH300 (I/O), PD80_ODT120_VOH300 (I/O), PD120_ODT120_VOH300 (I/O), PD240_ODT120_VOH300 (I/O), PD40_ODT240_VOH300 (I/O), PD48_ODT240_VOH300 (I/O), PD60_ODT240_VOH300 (I/O), PD80_ODT240_VOH300 (I/O), PD120_ODT240_VOH300 (I/O), PD240_ODT240_VOH300 (I/O), PD40_ODTDIS_VOH300 (I/O), PD48_ODTDIS_VOH300 (I/O), PD60_ODTDIS_VOH300 (I/O), PD80_ODTDIS_VOH300 (I/O), PD120_ODTDIS_VOH300 (I/O), PD240_ODTDIS_VOH300 (I/O), PD40_ODT60_VOH360 (I/O), PD48_ODT60_VOH360 (I/O), PD60_ODT60_VOH360 (I/O), PD80_ODT60_VOH360 (I/O), PD120_ODT60_VOH360 (I/O), PD240_ODT60_VOH360 (I/O), PD40_ODT120_VOH360 (I/O), PD48_ODT120_VOH360 (I/O), PD60_ODT120_VOH360 (I/O), PD80_ODT120_VOH360 (I/O), PD120_ODT120_VOH360 (I/O), PD240_ODT120_VOH360 (I/O), PD40_ODTDIS_VOH360 (I/O), PD48_ODTDIS_VOH360 (I/O), PD60_ODTDIS_VOH360 (I/O), PD80_ODTDIS_VOH360 (I/O), PD120_ODTDIS_VOH360 (I/O), PD240_ODTDIS_VOH360 (I/O), ODT_OFF (Input), ODT_40 (Input), ODT_48 (Input), ODT_60 (Input), ODT_80 (Input), ODT_120 (Input), ODT_240 (Input), CA_INPUT (Input), CA_ODT40 (Input), CA_ODT48 (Input), CA_ODT60 (Input), CA_ODT80 (Input), CA_ODT120 (Input), CA_ODT240 (Input), CS_INPUT (Input), CS_ODT40 (Input), CS_ODT48 (Input), CS_ODT60 (Input), CS_ODT80 (Input), CS_ODT120 (Input)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
