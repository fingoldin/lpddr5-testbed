| 4Gb LPDDR4x SDRAM
|Part Number   VDD1/VDD2//VDDQ   I/O   Type   Others
|W66CQ2NQUAFK   1.8V/1.1V/0.6V   32   DDP-WFBGA200L   1600MHz, -40C~105C
[IBIS Ver]  5.0
[File Name] w66cq2nquafk_a001.ibs
[File Rev]  001
[Date]   Jan 13, 2020
[Source]   From SPICE model at Winbond Electronics Corp.
[Notes]
   - IBIS Model Revision History:
   Rev 001: First release
[Disclaimer]  This software code and all associated documentation,
   comments or other information (collectively "Software") is
   provided "AS IS" without warranty of any kind. Winbond Electronics
   Corporation ("WEC") hereby DISCLAIMS ALL WARRANTIES EXPRESS
   OR IMPLIED, INCLUDING BUT NOT LIMITED TO, NONINFRINGEMENT
   OF THIRD PARTY RIGHTS, AND ANY IMPLIED WARRANTIES OF MERCHANTABILITY
   OR FITNESS FOR ANY PARTICULAR PURPOSE. WEC DOES NOT
   WARRANT THAT THE SOFTWARE WILL MEET YOUR REQUIREMENTS, OR THAT
   THE OPERATION OF THE SOFTWARE WILL BE UNINTERRUPTED OR ERROR-FREE.
   FURTHERMORE, WEC DOES NOT MAKE ANY REPRESENTATIONS REGARDING
   THE USE OR THE RESULTS OF THE USE OF THE SOFTWARE IN
   TERMS OF ITS CORRECTNESS, ACCURACY, RELIABILITY, OR OTHERWISE.
   THE ENTIRE RISK ARISING OUT OF USE OR PERFORMANCE OF THE SOFTWARE
   SHALL REMAIN WITH YOU. IN NO EVENT SHALL WEC, ITS AFFILIATED
   COMPANIES OR THEIR SUPPLIERS BE LIABLE FOR ANY DIRECT,
   INDIRECT, CONSEQUENTIAL, INCIDENTAL, OR SPECIAL DAMAGES (INCLUDING,
   WITHOUT LIMITATION, DAMAGES FOR LOSS OF PROFITS, BUSINESS
   INTERRUPTION, OR LOSS OF INFORMATION) ARISING OUT OF YOUR
   USE OF OR INABILITY TO USE THE SOFTWARE, EVEN IF WEC HAS BEEN
   ADVISED OF THE POSSIBILITY OF SUCH DAMAGES.
[Copyright] Copyright 2020 Winbond Electronics Corporation. All rights reserved
[Component]  W66CQ2NQUAFK
[Manufacturer] Winbond Electronics Corp.
[Package]
| variable   typ  min  max
R_pkg   1044.57m   668.08m   1845.1m
L_pkg   1.8819nH   1.175nH   3.364nH
C_pkg   0.7443pF   0.519pF   1.214pF
[Pin] Signal_Name   Model_Name  R_Pin  L_Pin C_Pin
H2   CA0_A   CA   1665.5m  2.951nH   1.1434pF
R2   CA0_B   CA   1785.5m  3.1845nH  1.1829pF
J2   CA1_A   CA   1721.2m  3.0428nH  1.1554pF
P2   CA1_B   CA   1845.1m  3.3526nH  1.2146pF
H9   CA2_A   CA   1322.8m  2.4358nH  0.93805pF
R9   CA2_B   CA   1581.2m  3.0404nH  1.0637pF
H10   CA3_A   CA   1494.7m  2.7012nH  1.0424pF
R10   CA3_B   CA   1779m   3.2782nH  1.1398pF
H11   CA4_A   CA   1596.3m  2.9606nH  1.1008pF
R11   CA4_B   CA   1620.2m  2.9451nH  1.0633pF
J11   CA5_A   CA   1715.2m  3.017nH   1.149pF
P11   CA5_B   CA   1720.6m  3.329nH   1.1681pF
J9   CK_C_A   CLK   1441.7m  2.6241nH  0.98941pF
P9   CK_C_B   CLK   1542.3m  2.7864nH  1.1034pF
J8   CK_T_A   CLK   1445.8m  2.6295nH  1.0317pF
P8   CK_T_B   CLK   1591.6m  2.8694nH  1.0666pF
J4   CKE0_A   CKE_IN  1417.5m  2.6163nH  1pF
P4   CKE0_B   CKE_IN  1769.6m  3.364nH   1.1367pF
H4   CS0_A   CS   1375.8m  2.4655nH  0.9637pF
R4   CS0_B   CS   1757.3m  3.3097nH  1.1366pF
C3   DMI0_A   I/O   809.15m  1.3981nH  0.63123pF
Y3   DMI0_B   I/O   793.62m  1.3916nH  0.59862pF
C10   DMI1_A   I/O   786.6m   1.3766nH  0.59978pF
Y10   DMI1_B   I/O   751.25m  1.3235nH  0.58247pF
B2   DQ0_A   I/O   748.2m   1.3074nH  0.54052pF
AA2   DQ0_B   I/O   766.33m  1.5845nH  0.53996pF
C2   DQ1_A   I/O   852.75m  1.4891nH  0.62208pF
Y2   DQ1_B   I/O   808.29m  1.3583nH  0.60022pF
E2   DQ2_A   I/O   821.6m   1.41nH   0.61471pF
V2   DQ2_B   I/O   782.02m  1.2787nH  0.58788pF
F2   DQ3_A   I/O   922.38m  1.5763nH  0.66736pF
U2   DQ3_B   I/O   922.54m  1.6078nH  0.68386pF
F4   DQ4_A   I/O   865.96m  1.501nH   0.63735pF
U4   DQ4_B   I/O   891.37m  1.516nH   0.63333pF
E4   DQ5_A   I/O   707.49m  1.2113nH  0.5573pF
V4   DQ5_B   I/O   822.7m   1.4116nH  0.58704pF
C4   DQ6_A   I/O   702.26m  1.2651nH  0.53069pF
Y4   DQ6_B   I/O   741.63m  1.3079nH  0.56897pF
B4   DQ7_A   I/O   719.51m  1.3255nH  0.56626pF
AA4   DQ7_B   I/O   740.15m  1.3778nH  0.55548pF
B11   DQ8_A   I/O   751.65m  1.3568nH  0.51916pF
AA11   DQ8_B   I/O   748.03m  1.4509nH  0.5282pF
C11   DQ9_A   I/O   726.08m  1.2429nH  0.54462pF
Y11   DQ9_B   I/O   822.21m  1.3575nH  0.63726pF
E11   DQ10_A   I/O   777.8m   1.3285nH  0.59177pF
V11   DQ10_B   I/O   791.74m  1.2937nH  0.58705pF
F11   DQ11_A   I/O   922.77m  1.5764nH  0.67355pF
U11   DQ11_B   I/O   932.78m  1.6596nH  0.67973pF
F9   DQ12_A   I/O   849.43m  1.4698nH  0.61819pF
U9   DQ12_B   I/O   872.05m  1.5364nH  0.61912pF
E9   DQ13_A   I/O   696.49m  1.1846nH  0.53538pF
V9   DQ13_B   I/O   792.13m  1.3772nH  0.56621pF
C9   DQ14_A   I/O   668.08m  1.1758nH  0.53075pF
Y9   DQ14_B   I/O   687.6m   1.1878nH  0.52252pF
B9   DQ15_A   I/O   713.87m  1.2702nH  0.54439pF
AA9   DQ15_B   I/O   727.36m  1.3079nH  0.55405pF
V3   DQS0_C_B  I/O   761.93m  1.4586nH  0.58584pF
E3   DQS0_C_A  I/O   791.34m  1.4642nH  0.59507pF
D3   DQS0_T_A  I/O   752.51m  1.3906nH  0.5698pF
W3   DQS0_T_B  I/O   808.35m  1.5198nH  0.59396pF
E10   DQS1_C_A  I/O   761.64m  1.4234nH  0.57487pF
V10   DQS1_C_B  I/O   812.13m  1.5639nH  0.59876pF
D10   DQS1_T_A  I/O   728.33m  1.3743nH  0.55194pF
W10   DQS1_T_B  I/O   812.09m  1.5543nH  0.61834pF
G2   ODT_CA_A  NC
T2   ODT_CA_B  NC
T11   RESET_N   NC
B1   SEN_A   NC
AA12   SEN_B   NC
A5   ZQ0   NC
U12   VDD1   POWER
AB9   VDD2   POWER
D12   VDDQ   POWER
G10   VSS   GND
[Diff Pin]   inv_pin   vdiff   tdelay_typ   tdelay_min   tdelay_max
D3   E3   0.280V   0.000s   NA   NA
W3   V3   0.280V   0.000s   NA   NA
D10   E10   0.280V   0.000s   NA   NA
W10   V10   0.280V   0.000s   NA   NA
J8   J9   0.310V   0.000s   NA   NA
P8   P9   0.310V   0.000s   NA   NA
[Model Selector]   I/O
PD40_ODT40_VOH300   Pulldown driver 40  Ohm,  40 Ohm System ODT,  VOH=VDDQ*0.5
PD48_ODT40_VOH300   Pulldown driver 48  Ohm,  40 Ohm System ODT,  VOH=VDDQ*0.5
PD60_ODT40_VOH300   Pulldown driver 60  Ohm,  40 Ohm System ODT,  VOH=VDDQ*0.5
PD80_ODT40_VOH300   Pulldown driver 80  Ohm,  40 Ohm System ODT,  VOH=VDDQ*0.5
PD120_ODT40_VOH300   Pulldown driver 120 Ohm,  40 Ohm System ODT,  VOH=VDDQ*0.5
PD240_ODT40_VOH300   Pulldown driver 240 Ohm,  40 Ohm System ODT,  VOH=VDDQ*0.5
PD40_ODT48_VOH300   Pulldown driver 40  Ohm,  48 Ohm System ODT,  VOH=VDDQ*0.5
PD48_ODT48_VOH300   Pulldown driver 48  Ohm,  48 Ohm System ODT,  VOH=VDDQ*0.5
PD60_ODT48_VOH300   Pulldown driver 60  Ohm,  48 Ohm System ODT,  VOH=VDDQ*0.5
PD80_ODT48_VOH300   Pulldown driver 80  Ohm,  48 Ohm System ODT,  VOH=VDDQ*0.5
PD120_ODT48_VOH300   Pulldown driver 120 Ohm,  48 Ohm System ODT,  VOH=VDDQ*0.5
PD240_ODT48_VOH300   Pulldown driver 240 Ohm,  48 Ohm System ODT,  VOH=VDDQ*0.5
PD40_ODT60_VOH300   Pulldown driver 40  Ohm,  60 Ohm System ODT,  VOH=VDDQ*0.5
PD48_ODT60_VOH300   Pulldown driver 48  Ohm,  60 Ohm System ODT,  VOH=VDDQ*0.5
PD60_ODT60_VOH300   Pulldown driver 60  Ohm,  60 Ohm System ODT,  VOH=VDDQ*0.5
PD80_ODT60_VOH300   Pulldown driver 80  Ohm,  60 Ohm System ODT,  VOH=VDDQ*0.5
PD120_ODT60_VOH300   Pulldown driver 120 Ohm,  60 Ohm System ODT,  VOH=VDDQ*0.5
PD240_ODT60_VOH300   Pulldown driver 240 Ohm,  60 Ohm System ODT,  VOH=VDDQ*0.5
PD40_ODT80_VOH300   Pulldown driver 40  Ohm,  80 Ohm System ODT,  VOH=VDDQ*0.5
PD48_ODT80_VOH300   Pulldown driver 48  Ohm,  80 Ohm System ODT,  VOH=VDDQ*0.5
PD60_ODT80_VOH300   Pulldown driver 60  Ohm,  80 Ohm System ODT,  VOH=VDDQ*0.5
PD80_ODT80_VOH300   Pulldown driver 80  Ohm,  80 Ohm System ODT,  VOH=VDDQ*0.5
PD120_ODT80_VOH300   Pulldown driver 120 Ohm,  80 Ohm System ODT,  VOH=VDDQ*0.5
PD240_ODT80_VOH300   Pulldown driver 240 Ohm,  80 Ohm System ODT,  VOH=VDDQ*0.5
PD40_ODT120_VOH300   Pulldown driver 40  Ohm,  120 Ohm System ODT, VOH=VDDQ*0.5
PD48_ODT120_VOH300   Pulldown driver 48  Ohm,  120 Ohm System ODT, VOH=VDDQ*0.5
PD60_ODT120_VOH300   Pulldown driver 60  Ohm,  120 Ohm System ODT, VOH=VDDQ*0.5
PD80_ODT120_VOH300   Pulldown driver 80  Ohm,  120 Ohm System ODT, VOH=VDDQ*0.5
PD120_ODT120_VOH300  Pulldown driver 120 Ohm,  120 Ohm System ODT, VOH=VDDQ*0.5
PD240_ODT120_VOH300  Pulldown driver 240 Ohm,  120 Ohm System ODT, VOH=VDDQ*0.5
PD40_ODT240_VOH300   Pulldown driver 40  Ohm,  240 Ohm System ODT, VOH=VDDQ*0.5
PD48_ODT240_VOH300   Pulldown driver 48  Ohm,  240 Ohm System ODT, VOH=VDDQ*0.5
PD60_ODT240_VOH300   Pulldown driver 60  Ohm,  240 Ohm System ODT, VOH=VDDQ*0.5
PD80_ODT240_VOH300   Pulldown driver 80  Ohm,  240 Ohm System ODT, VOH=VDDQ*0.5
PD120_ODT240_VOH300  Pulldown driver 120 Ohm,  240 Ohm System ODT, VOH=VDDQ*0.5
PD240_ODT240_VOH300  Pulldown driver 240 Ohm,  240 Ohm System ODT, VOH=VDDQ*0.5
PD40_ODTDIS_VOH300   Pulldown driver 40  Ohm,  DIS System ODT,   VOH=VDDQ*0.5
PD48_ODTDIS_VOH300   Pulldown driver 48  Ohm,  DIS System ODT,   VOH=VDDQ*0.5
PD60_ODTDIS_VOH300   Pulldown driver 60  Ohm,  DIS System ODT,   VOH=VDDQ*0.5
PD80_ODTDIS_VOH300   Pulldown driver 80  Ohm,  DIS System ODT,   VOH=VDDQ*0.5
PD120_ODTDIS_VOH300  Pulldown driver 120 Ohm,  DIS System ODT,   VOH=VDDQ*0.5
PD240_ODTDIS_VOH300  Pulldown driver 240 Ohm,  DIS System ODT,   VOH=VDDQ*0.5
PD40_ODT60_VOH360   Pulldown driver 40  Ohm,  60 Ohm System ODT,  VOH=VDDQ*0.6
PD48_ODT60_VOH360   Pulldown driver 48  Ohm,  60 Ohm System ODT,  VOH=VDDQ*0.6
PD60_ODT60_VOH360   Pulldown driver 60  Ohm,  60 Ohm System ODT,  VOH=VDDQ*0.6
PD80_ODT60_VOH360   Pulldown driver 80  Ohm,  60 Ohm System ODT,  VOH=VDDQ*0.6
PD120_ODT60_VOH360   Pulldown driver 120 Ohm,  60 Ohm System ODT,  VOH=VDDQ*0.6
PD240_ODT60_VOH360   Pulldown driver 240 Ohm,  60 Ohm System ODT,  VOH=VDDQ*0.6
PD40_ODT120_VOH360   Pulldown driver 40  Ohm,  120 Ohm System ODT, VOH=VDDQ*0.6
PD48_ODT120_VOH360   Pulldown driver 48  Ohm,  120 Ohm System ODT, VOH=VDDQ*0.6
PD60_ODT120_VOH360   Pulldown driver 60  Ohm,  120 Ohm System ODT, VOH=VDDQ*0.6
PD80_ODT120_VOH360   Pulldown driver 80  Ohm,  120 Ohm System ODT, VOH=VDDQ*0.6
PD120_ODT120_VOH360  Pulldown driver 120 Ohm,  120 Ohm System ODT, VOH=VDDQ*0.6
PD240_ODT120_VOH360  Pulldown driver 240 Ohm,  120 Ohm System ODT, VOH=VDDQ*0.6
PD40_ODTDIS_VOH360   Pulldown driver 40  Ohm,  DIS System ODT,   VOH=VDDQ*0.6
PD48_ODTDIS_VOH360   Pulldown driver 48  Ohm,  DIS System ODT,   VOH=VDDQ*0.6
PD60_ODTDIS_VOH360   Pulldown driver 60  Ohm,  DIS System ODT,   VOH=VDDQ*0.6
PD80_ODTDIS_VOH360   Pulldown driver 80  Ohm,  DIS System ODT,   VOH=VDDQ*0.6
PD120_ODTDIS_VOH360  Pulldown driver 120 Ohm,  DIS System ODT,   VOH=VDDQ*0.6
PD240_ODTDIS_VOH360  Pulldown driver 240 Ohm,  DIS System ODT,   VOH=VDDQ*0.6
ODT_OFF   ODT OFF
ODT_40   ODT 40  Ohm
ODT_48   ODT 48  Ohm
ODT_60   ODT 60  Ohm
ODT_80   ODT 80  Ohm
ODT_120   ODT 120 Ohm
ODT_240   ODT 240 Ohm
[Model Selector]   CA
CA_INPUT   ODT OFF
CA_ODT40   ODT 40  Ohm
CA_ODT48   ODT 48  Ohm
CA_ODT60   ODT 60  Ohm
CA_ODT80   ODT 80  Ohm
CA_ODT120   ODT 120 Ohm
CA_ODT240   ODT 240 Ohm
[Model Selector]   CS
CS_INPUT   ODT OFF
CS_ODT40   ODT 40  Ohm
CS_ODT48   ODT 48  Ohm
CS_ODT60   ODT 60  Ohm
CS_ODT80   ODT 80  Ohm
CS_ODT120   ODT 120 Ohm
CS_ODT240   ODT 240 Ohm
[Model Selector]   CLK
CLK_INPUT   ODT OFF
CLK_ODT40   ODT 40  Ohm
CLK_ODT48   ODT 48  Ohm
CLK_ODT60   ODT 60  Ohm
CLK_ODT80   ODT 80  Ohm
CLK_ODT120   ODT 120 Ohm
CLK_ODT240   ODT 240 Ohm
| Models and submodels in the file (89): PD40_ODT40_VOH300 (I/O), PD48_ODT40_VOH300 (I/O), PD60_ODT40_VOH300 (I/O), PD80_ODT40_VOH300 (I/O), PD120_ODT40_VOH300 (I/O), PD240_ODT40_VOH300 (I/O), PD40_ODT48_VOH300 (I/O), PD48_ODT48_VOH300 (I/O), PD60_ODT48_VOH300 (I/O), PD80_ODT48_VOH300 (I/O), PD120_ODT48_VOH300 (I/O), PD240_ODT48_VOH300 (I/O), PD40_ODT60_VOH300 (I/O), PD48_ODT60_VOH300 (I/O), PD60_ODT60_VOH300 (I/O), PD80_ODT60_VOH300 (I/O), PD120_ODT60_VOH300 (I/O), PD240_ODT60_VOH300 (I/O), PD40_ODT80_VOH300 (I/O), PD48_ODT80_VOH300 (I/O), PD60_ODT80_VOH300 (I/O), PD80_ODT80_VOH300 (I/O), PD120_ODT80_VOH300 (I/O), PD240_ODT80_VOH300 (I/O), PD40_ODT120_VOH300 (I/O), PD48_ODT120_VOH300 (I/O), PD60_ODT120_VOH300 (I/O), PD80_ODT120_VOH300 (I/O), PD120_ODT120_VOH300 (I/O), PD240_ODT120_VOH300 (I/O), PD40_ODT240_VOH300 (I/O), PD48_ODT240_VOH300 (I/O), PD60_ODT240_VOH300 (I/O), PD80_ODT240_VOH300 (I/O), PD120_ODT240_VOH300 (I/O), PD240_ODT240_VOH300 (I/O), PD40_ODTDIS_VOH300 (I/O), PD48_ODTDIS_VOH300 (I/O), PD60_ODTDIS_VOH300 (I/O), PD80_ODTDIS_VOH300 (I/O), PD120_ODTDIS_VOH300 (I/O), PD240_ODTDIS_VOH300 (I/O), PD40_ODT60_VOH360 (I/O), PD48_ODT60_VOH360 (I/O), PD60_ODT60_VOH360 (I/O), PD80_ODT60_VOH360 (I/O), PD120_ODT60_VOH360 (I/O), PD240_ODT60_VOH360 (I/O), PD40_ODT120_VOH360 (I/O), PD48_ODT120_VOH360 (I/O), PD60_ODT120_VOH360 (I/O), PD80_ODT120_VOH360 (I/O), PD120_ODT120_VOH360 (I/O), PD240_ODT120_VOH360 (I/O), PD40_ODTDIS_VOH360 (I/O), PD48_ODTDIS_VOH360 (I/O), PD60_ODTDIS_VOH360 (I/O), PD80_ODTDIS_VOH360 (I/O), PD120_ODTDIS_VOH360 (I/O), PD240_ODTDIS_VOH360 (I/O), ODT_OFF (Input), ODT_40 (Input), ODT_48 (Input), ODT_60 (Input), ODT_80 (Input), ODT_120 (Input), ODT_240 (Input), CA_INPUT (Input), CA_ODT40 (Input), CA_ODT48 (Input), CA_ODT60 (Input), CA_ODT80 (Input), CA_ODT120 (Input), CA_ODT240 (Input), CS_INPUT (Input), CS_ODT40 (Input), CS_ODT48 (Input), CS_ODT60 (Input), CS_ODT80 (Input), CS_ODT120 (Input)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
